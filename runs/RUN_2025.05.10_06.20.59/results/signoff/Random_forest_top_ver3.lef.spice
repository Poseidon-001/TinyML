* NGSPICE file created from Random_forest_top_ver3.ext - technology: sky130A

* Black-box entry subcircuit for sky130_fd_sc_hd__diode_2 abstract view
.subckt sky130_fd_sc_hd__diode_2 DIODE VGND VNB VPB VPWR
.ends

* Black-box entry subcircuit for sky130_fd_sc_hd__fill_2 abstract view
.subckt sky130_fd_sc_hd__fill_2 VGND VNB VPB VPWR
.ends

* Black-box entry subcircuit for sky130_fd_sc_hd__o22a_1 abstract view
.subckt sky130_fd_sc_hd__o22a_1 A1 A2 B1 B2 VGND VNB VPB VPWR X
.ends

* Black-box entry subcircuit for sky130_fd_sc_hd__xor2_1 abstract view
.subckt sky130_fd_sc_hd__xor2_1 A B VGND VNB VPB VPWR X
.ends

* Black-box entry subcircuit for sky130_fd_sc_hd__decap_4 abstract view
.subckt sky130_fd_sc_hd__decap_4 VGND VNB VPB VPWR
.ends

* Black-box entry subcircuit for sky130_fd_sc_hd__decap_8 abstract view
.subckt sky130_fd_sc_hd__decap_8 VGND VNB VPB VPWR
.ends

* Black-box entry subcircuit for sky130_fd_sc_hd__fill_1 abstract view
.subckt sky130_fd_sc_hd__fill_1 VGND VNB VPB VPWR
.ends

* Black-box entry subcircuit for sky130_fd_sc_hd__clkbuf_1 abstract view
.subckt sky130_fd_sc_hd__clkbuf_1 A VGND VNB VPB VPWR X
.ends

* Black-box entry subcircuit for sky130_ef_sc_hd__decap_12 abstract view
.subckt sky130_ef_sc_hd__decap_12 VPWR VGND VPB VNB
.ends

* Black-box entry subcircuit for sky130_fd_sc_hd__inv_2 abstract view
.subckt sky130_fd_sc_hd__inv_2 A VGND VNB VPB VPWR Y
.ends

* Black-box entry subcircuit for sky130_fd_sc_hd__decap_6 abstract view
.subckt sky130_fd_sc_hd__decap_6 VGND VNB VPB VPWR
.ends

* Black-box entry subcircuit for sky130_fd_sc_hd__dfrtp_1 abstract view
.subckt sky130_fd_sc_hd__dfrtp_1 CLK D RESET_B VGND VNB VPB VPWR Q
.ends

* Black-box entry subcircuit for sky130_fd_sc_hd__tapvpwrvgnd_1 abstract view
.subckt sky130_fd_sc_hd__tapvpwrvgnd_1 VGND VPWR
.ends

* Black-box entry subcircuit for sky130_fd_sc_hd__decap_3 abstract view
.subckt sky130_fd_sc_hd__decap_3 VGND VNB VPB VPWR
.ends

* Black-box entry subcircuit for sky130_fd_sc_hd__mux2_1 abstract view
.subckt sky130_fd_sc_hd__mux2_1 A0 A1 S VGND VNB VPB VPWR X
.ends

* Black-box entry subcircuit for sky130_fd_sc_hd__and2_1 abstract view
.subckt sky130_fd_sc_hd__and2_1 A B VGND VNB VPB VPWR X
.ends

* Black-box entry subcircuit for sky130_fd_sc_hd__or4_1 abstract view
.subckt sky130_fd_sc_hd__or4_1 A B C D VGND VNB VPB VPWR X
.ends

* Black-box entry subcircuit for sky130_fd_sc_hd__a22o_1 abstract view
.subckt sky130_fd_sc_hd__a22o_1 A1 A2 B1 B2 VGND VNB VPB VPWR X
.ends

* Black-box entry subcircuit for sky130_fd_sc_hd__a2bb2o_1 abstract view
.subckt sky130_fd_sc_hd__a2bb2o_1 A1_N A2_N B1 B2 VGND VNB VPB VPWR X
.ends

* Black-box entry subcircuit for sky130_fd_sc_hd__a21o_1 abstract view
.subckt sky130_fd_sc_hd__a21o_1 A1 A2 B1 VGND VNB VPB VPWR X
.ends

* Black-box entry subcircuit for sky130_fd_sc_hd__or2_1 abstract view
.subckt sky130_fd_sc_hd__or2_1 A B VGND VNB VPB VPWR X
.ends

* Black-box entry subcircuit for sky130_fd_sc_hd__or3_1 abstract view
.subckt sky130_fd_sc_hd__or3_1 A B C VGND VNB VPB VPWR X
.ends

* Black-box entry subcircuit for sky130_fd_sc_hd__nor2_1 abstract view
.subckt sky130_fd_sc_hd__nor2_1 A B VGND VNB VPB VPWR Y
.ends

* Black-box entry subcircuit for sky130_fd_sc_hd__xnor2_1 abstract view
.subckt sky130_fd_sc_hd__xnor2_1 A B VGND VNB VPB VPWR Y
.ends

* Black-box entry subcircuit for sky130_fd_sc_hd__buf_8 abstract view
.subckt sky130_fd_sc_hd__buf_8 A VGND VNB VPB VPWR X
.ends

* Black-box entry subcircuit for sky130_fd_sc_hd__dfstp_1 abstract view
.subckt sky130_fd_sc_hd__dfstp_1 CLK D SET_B VGND VNB VPB VPWR Q
.ends

* Black-box entry subcircuit for sky130_fd_sc_hd__nand2_1 abstract view
.subckt sky130_fd_sc_hd__nand2_1 A B VGND VNB VPB VPWR Y
.ends

* Black-box entry subcircuit for sky130_fd_sc_hd__clkbuf_16 abstract view
.subckt sky130_fd_sc_hd__clkbuf_16 A VGND VNB VPB VPWR X
.ends

* Black-box entry subcircuit for sky130_fd_sc_hd__a211oi_1 abstract view
.subckt sky130_fd_sc_hd__a211oi_1 A1 A2 B1 C1 VGND VNB VPB VPWR Y
.ends

* Black-box entry subcircuit for sky130_fd_sc_hd__and4b_1 abstract view
.subckt sky130_fd_sc_hd__and4b_1 A_N B C D VGND VNB VPB VPWR X
.ends

* Black-box entry subcircuit for sky130_fd_sc_hd__dlymetal6s2s_1 abstract view
.subckt sky130_fd_sc_hd__dlymetal6s2s_1 A VGND VNB VPB VPWR X
.ends

* Black-box entry subcircuit for sky130_fd_sc_hd__o2bb2a_1 abstract view
.subckt sky130_fd_sc_hd__o2bb2a_1 A1_N A2_N B1 B2 VGND VNB VPB VPWR X
.ends

* Black-box entry subcircuit for sky130_fd_sc_hd__clkbuf_4 abstract view
.subckt sky130_fd_sc_hd__clkbuf_4 A VGND VNB VPB VPWR X
.ends

* Black-box entry subcircuit for sky130_fd_sc_hd__buf_2 abstract view
.subckt sky130_fd_sc_hd__buf_2 A VGND VNB VPB VPWR X
.ends

* Black-box entry subcircuit for sky130_fd_sc_hd__and3_1 abstract view
.subckt sky130_fd_sc_hd__and3_1 A B C VGND VNB VPB VPWR X
.ends

* Black-box entry subcircuit for sky130_fd_sc_hd__o211a_1 abstract view
.subckt sky130_fd_sc_hd__o211a_1 A1 A2 B1 C1 VGND VNB VPB VPWR X
.ends

* Black-box entry subcircuit for sky130_fd_sc_hd__a221o_1 abstract view
.subckt sky130_fd_sc_hd__a221o_1 A1 A2 B1 B2 C1 VGND VNB VPB VPWR X
.ends

* Black-box entry subcircuit for sky130_fd_sc_hd__buf_1 abstract view
.subckt sky130_fd_sc_hd__buf_1 A VGND VNB VPB VPWR X
.ends

* Black-box entry subcircuit for sky130_fd_sc_hd__and2b_1 abstract view
.subckt sky130_fd_sc_hd__and2b_1 A_N B VGND VNB VPB VPWR X
.ends

* Black-box entry subcircuit for sky130_fd_sc_hd__a21oi_1 abstract view
.subckt sky130_fd_sc_hd__a21oi_1 A1 A2 B1 VGND VNB VPB VPWR Y
.ends

* Black-box entry subcircuit for sky130_fd_sc_hd__and3b_1 abstract view
.subckt sky130_fd_sc_hd__and3b_1 A_N B C VGND VNB VPB VPWR X
.ends

* Black-box entry subcircuit for sky130_fd_sc_hd__a31o_1 abstract view
.subckt sky130_fd_sc_hd__a31o_1 A1 A2 A3 B1 VGND VNB VPB VPWR X
.ends

* Black-box entry subcircuit for sky130_fd_sc_hd__a2111o_1 abstract view
.subckt sky130_fd_sc_hd__a2111o_1 A1 A2 B1 C1 D1 VGND VNB VPB VPWR X
.ends

* Black-box entry subcircuit for sky130_fd_sc_hd__o2111a_1 abstract view
.subckt sky130_fd_sc_hd__o2111a_1 A1 A2 B1 C1 D1 VGND VNB VPB VPWR X
.ends

* Black-box entry subcircuit for sky130_fd_sc_hd__o211ai_1 abstract view
.subckt sky130_fd_sc_hd__o211ai_1 A1 A2 B1 C1 VGND VNB VPB VPWR Y
.ends

* Black-box entry subcircuit for sky130_fd_sc_hd__and4_1 abstract view
.subckt sky130_fd_sc_hd__and4_1 A B C D VGND VNB VPB VPWR X
.ends

* Black-box entry subcircuit for sky130_fd_sc_hd__o221a_1 abstract view
.subckt sky130_fd_sc_hd__o221a_1 A1 A2 B1 B2 C1 VGND VNB VPB VPWR X
.ends

* Black-box entry subcircuit for sky130_fd_sc_hd__clkinvlp_4 abstract view
.subckt sky130_fd_sc_hd__clkinvlp_4 A VGND VNB VPB VPWR Y
.ends

* Black-box entry subcircuit for sky130_fd_sc_hd__a221oi_1 abstract view
.subckt sky130_fd_sc_hd__a221oi_1 A1 A2 B1 B2 C1 VGND VNB VPB VPWR Y
.ends

* Black-box entry subcircuit for sky130_fd_sc_hd__a211o_1 abstract view
.subckt sky130_fd_sc_hd__a211o_1 A1 A2 B1 C1 VGND VNB VPB VPWR X
.ends

* Black-box entry subcircuit for sky130_fd_sc_hd__or3b_1 abstract view
.subckt sky130_fd_sc_hd__or3b_1 A B C_N VGND VNB VPB VPWR X
.ends

* Black-box entry subcircuit for sky130_fd_sc_hd__buf_12 abstract view
.subckt sky130_fd_sc_hd__buf_12 A VGND VNB VPB VPWR X
.ends

* Black-box entry subcircuit for sky130_fd_sc_hd__clkinv_4 abstract view
.subckt sky130_fd_sc_hd__clkinv_4 A VGND VNB VPB VPWR Y
.ends

* Black-box entry subcircuit for sky130_fd_sc_hd__inv_6 abstract view
.subckt sky130_fd_sc_hd__inv_6 A VGND VNB VPB VPWR Y
.ends

* Black-box entry subcircuit for sky130_fd_sc_hd__nor3_1 abstract view
.subckt sky130_fd_sc_hd__nor3_1 A B C VGND VNB VPB VPWR Y
.ends

* Black-box entry subcircuit for sky130_fd_sc_hd__o21a_1 abstract view
.subckt sky130_fd_sc_hd__o21a_1 A1 A2 B1 VGND VNB VPB VPWR X
.ends

* Black-box entry subcircuit for sky130_fd_sc_hd__bufinv_16 abstract view
.subckt sky130_fd_sc_hd__bufinv_16 A VGND VNB VPB VPWR Y
.ends

* Black-box entry subcircuit for sky130_fd_sc_hd__o31a_1 abstract view
.subckt sky130_fd_sc_hd__o31a_1 A1 A2 A3 B1 VGND VNB VPB VPWR X
.ends

* Black-box entry subcircuit for sky130_fd_sc_hd__buf_4 abstract view
.subckt sky130_fd_sc_hd__buf_4 A VGND VNB VPB VPWR X
.ends

* Black-box entry subcircuit for sky130_fd_sc_hd__clkinv_1 abstract view
.subckt sky130_fd_sc_hd__clkinv_1 A VGND VNB VPB VPWR Y
.ends

* Black-box entry subcircuit for sky130_fd_sc_hd__dfrtp_4 abstract view
.subckt sky130_fd_sc_hd__dfrtp_4 CLK D RESET_B VGND VNB VPB VPWR Q
.ends

* Black-box entry subcircuit for sky130_fd_sc_hd__clkinvlp_2 abstract view
.subckt sky130_fd_sc_hd__clkinvlp_2 A VGND VNB VPB VPWR Y
.ends

* Black-box entry subcircuit for sky130_fd_sc_hd__inv_8 abstract view
.subckt sky130_fd_sc_hd__inv_8 A VGND VNB VPB VPWR Y
.ends

* Black-box entry subcircuit for sky130_fd_sc_hd__o21ai_1 abstract view
.subckt sky130_fd_sc_hd__o21ai_1 A1 A2 B1 VGND VNB VPB VPWR Y
.ends

* Black-box entry subcircuit for sky130_fd_sc_hd__clkinv_2 abstract view
.subckt sky130_fd_sc_hd__clkinv_2 A VGND VNB VPB VPWR Y
.ends

* Black-box entry subcircuit for sky130_fd_sc_hd__a41o_1 abstract view
.subckt sky130_fd_sc_hd__a41o_1 A1 A2 A3 A4 B1 VGND VNB VPB VPWR X
.ends

* Black-box entry subcircuit for sky130_fd_sc_hd__clkbuf_2 abstract view
.subckt sky130_fd_sc_hd__clkbuf_2 A VGND VNB VPB VPWR X
.ends

* Black-box entry subcircuit for sky130_fd_sc_hd__conb_1 abstract view
.subckt sky130_fd_sc_hd__conb_1 VGND VNB VPB VPWR HI LO
.ends

* Black-box entry subcircuit for sky130_fd_sc_hd__o31ai_1 abstract view
.subckt sky130_fd_sc_hd__o31ai_1 A1 A2 A3 B1 VGND VNB VPB VPWR Y
.ends

* Black-box entry subcircuit for sky130_fd_sc_hd__o41a_1 abstract view
.subckt sky130_fd_sc_hd__o41a_1 A1 A2 A3 A4 B1 VGND VNB VPB VPWR X
.ends

* Black-box entry subcircuit for sky130_fd_sc_hd__nor2_2 abstract view
.subckt sky130_fd_sc_hd__nor2_2 A B VGND VNB VPB VPWR Y
.ends

* Black-box entry subcircuit for sky130_fd_sc_hd__clkinv_8 abstract view
.subckt sky130_fd_sc_hd__clkinv_8 A VGND VNB VPB VPWR Y
.ends

* Black-box entry subcircuit for sky130_fd_sc_hd__a32o_1 abstract view
.subckt sky130_fd_sc_hd__a32o_1 A1 A2 A3 B1 B2 VGND VNB VPB VPWR X
.ends

* Black-box entry subcircuit for sky130_fd_sc_hd__dfrtp_2 abstract view
.subckt sky130_fd_sc_hd__dfrtp_2 CLK D RESET_B VGND VNB VPB VPWR Q
.ends

* Black-box entry subcircuit for sky130_fd_sc_hd__nand3_1 abstract view
.subckt sky130_fd_sc_hd__nand3_1 A B C VGND VNB VPB VPWR Y
.ends

* Black-box entry subcircuit for sky130_fd_sc_hd__a22oi_1 abstract view
.subckt sky130_fd_sc_hd__a22oi_1 A1 A2 B1 B2 VGND VNB VPB VPWR Y
.ends

* Black-box entry subcircuit for sky130_fd_sc_hd__and4bb_1 abstract view
.subckt sky130_fd_sc_hd__and4bb_1 A_N B_N C D VGND VNB VPB VPWR X
.ends

* Black-box entry subcircuit for sky130_fd_sc_hd__or2b_1 abstract view
.subckt sky130_fd_sc_hd__or2b_1 A B_N VGND VNB VPB VPWR X
.ends

* Black-box entry subcircuit for sky130_fd_sc_hd__a2111oi_1 abstract view
.subckt sky130_fd_sc_hd__a2111oi_1 A1 A2 B1 C1 D1 VGND VNB VPB VPWR Y
.ends

* Black-box entry subcircuit for sky130_fd_sc_hd__dlygate4sd3_1 abstract view
.subckt sky130_fd_sc_hd__dlygate4sd3_1 A VGND VNB VPB VPWR X
.ends

* Black-box entry subcircuit for sky130_fd_sc_hd__nor4_1 abstract view
.subckt sky130_fd_sc_hd__nor4_1 A B C D VGND VNB VPB VPWR Y
.ends

* Black-box entry subcircuit for sky130_fd_sc_hd__a21boi_1 abstract view
.subckt sky130_fd_sc_hd__a21boi_1 A1 A2 B1_N VGND VNB VPB VPWR Y
.ends

* Black-box entry subcircuit for sky130_fd_sc_hd__or2_2 abstract view
.subckt sky130_fd_sc_hd__or2_2 A B VGND VNB VPB VPWR X
.ends

* Black-box entry subcircuit for sky130_fd_sc_hd__o22ai_1 abstract view
.subckt sky130_fd_sc_hd__o22ai_1 A1 A2 B1 B2 VGND VNB VPB VPWR Y
.ends

* Black-box entry subcircuit for sky130_fd_sc_hd__o311a_1 abstract view
.subckt sky130_fd_sc_hd__o311a_1 A1 A2 A3 B1 C1 VGND VNB VPB VPWR X
.ends

* Black-box entry subcircuit for sky130_fd_sc_hd__or4bb_1 abstract view
.subckt sky130_fd_sc_hd__or4bb_1 A B C_N D_N VGND VNB VPB VPWR X
.ends

.subckt Random_forest_top_ver3 VGND VPWR arbitration_id[0] arbitration_id[10] arbitration_id[11]
+ arbitration_id[12] arbitration_id[13] arbitration_id[14] arbitration_id[15] arbitration_id[16]
+ arbitration_id[17] arbitration_id[18] arbitration_id[19] arbitration_id[1] arbitration_id[20]
+ arbitration_id[21] arbitration_id[22] arbitration_id[23] arbitration_id[24] arbitration_id[25]
+ arbitration_id[26] arbitration_id[27] arbitration_id[28] arbitration_id[29] arbitration_id[2]
+ arbitration_id[30] arbitration_id[31] arbitration_id[32] arbitration_id[33] arbitration_id[34]
+ arbitration_id[35] arbitration_id[36] arbitration_id[37] arbitration_id[38] arbitration_id[39]
+ arbitration_id[3] arbitration_id[40] arbitration_id[41] arbitration_id[42] arbitration_id[43]
+ arbitration_id[44] arbitration_id[45] arbitration_id[46] arbitration_id[47] arbitration_id[48]
+ arbitration_id[49] arbitration_id[4] arbitration_id[50] arbitration_id[51] arbitration_id[52]
+ arbitration_id[53] arbitration_id[54] arbitration_id[55] arbitration_id[56] arbitration_id[57]
+ arbitration_id[58] arbitration_id[59] arbitration_id[5] arbitration_id[60] arbitration_id[61]
+ arbitration_id[62] arbitration_id[63] arbitration_id[6] arbitration_id[7] arbitration_id[8]
+ arbitration_id[9] clk data_field[0] data_field[10] data_field[11] data_field[12]
+ data_field[13] data_field[14] data_field[15] data_field[16] data_field[17] data_field[18]
+ data_field[19] data_field[1] data_field[20] data_field[21] data_field[22] data_field[23]
+ data_field[24] data_field[25] data_field[26] data_field[27] data_field[28] data_field[29]
+ data_field[2] data_field[30] data_field[31] data_field[32] data_field[33] data_field[34]
+ data_field[35] data_field[36] data_field[37] data_field[38] data_field[39] data_field[3]
+ data_field[40] data_field[41] data_field[42] data_field[43] data_field[44] data_field[45]
+ data_field[46] data_field[47] data_field[48] data_field[49] data_field[4] data_field[50]
+ data_field[51] data_field[52] data_field[53] data_field[54] data_field[55] data_field[56]
+ data_field[57] data_field[58] data_field[59] data_field[5] data_field[60] data_field[61]
+ data_field[62] data_field[63] data_field[6] data_field[7] data_field[8] data_field[9]
+ feature_valid frame_id_out[0] frame_id_out[1] frame_id_out[2] frame_id_out[3] frame_id_out[4]
+ prediction_valid ready_for_next rst_n timestamp[0] timestamp[10] timestamp[11] timestamp[12]
+ timestamp[13] timestamp[14] timestamp[15] timestamp[16] timestamp[17] timestamp[18]
+ timestamp[19] timestamp[1] timestamp[20] timestamp[21] timestamp[22] timestamp[23]
+ timestamp[24] timestamp[25] timestamp[26] timestamp[27] timestamp[28] timestamp[29]
+ timestamp[2] timestamp[30] timestamp[31] timestamp[32] timestamp[33] timestamp[34]
+ timestamp[35] timestamp[36] timestamp[37] timestamp[38] timestamp[39] timestamp[3]
+ timestamp[40] timestamp[41] timestamp[42] timestamp[43] timestamp[44] timestamp[45]
+ timestamp[46] timestamp[47] timestamp[48] timestamp[49] timestamp[4] timestamp[50]
+ timestamp[51] timestamp[52] timestamp[53] timestamp[54] timestamp[55] timestamp[56]
+ timestamp[57] timestamp[58] timestamp[59] timestamp[5] timestamp[60] timestamp[61]
+ timestamp[62] timestamp[63] timestamp[6] timestamp[7] timestamp[8] timestamp[9]
+ prediction_out
XANTENNA__3140__A1 _0686_ VGND VGND VPWR VPWR sky130_fd_sc_hd__diode_2
XFILLER_0_94_88 VGND VGND VPWR VPWR sky130_fd_sc_hd__fill_2
X_3155_ _0648_ tree_instances\[10\].u_tree.frame_id_out\[0\] _0826_ _0655_ VGND VGND
+ VPWR VPWR _0827_ sky130_fd_sc_hd__o22a_1
XANTENNA__3140__B2 _0691_ VGND VGND VPWR VPWR sky130_fd_sc_hd__diode_2
X_3086_ _0661_ tree_instances\[18\].u_tree.frame_id_out\[4\] VGND VGND VPWR VPWR _0758_
+ sky130_fd_sc_hd__xor2_1
XFILLER_0_76_166 VGND VGND VPWR VPWR sky130_fd_sc_hd__decap_4
XFILLER_0_64_306 VGND VGND VPWR VPWR sky130_fd_sc_hd__fill_2
XFILLER_0_37_509 VGND VGND VPWR VPWR sky130_fd_sc_hd__decap_8
XFILLER_0_91_125 VGND VGND VPWR VPWR sky130_fd_sc_hd__fill_1
X_3988_ _1355_ VGND VGND VPWR VPWR _0420_ sky130_fd_sc_hd__clkbuf_1
XANTENNA__4837__RESET_B net13 VGND VGND VPWR VPWR sky130_fd_sc_hd__diode_2
XFILLER_0_91_169 VPWR VGND VPWR VGND sky130_ef_sc_hd__decap_12
XFILLER_0_72_350 VGND VGND VPWR VPWR sky130_fd_sc_hd__fill_1
X_2939_ tree_instances\[3\].u_tree.tree_state\[0\] VGND VGND VPWR VPWR _0629_ sky130_fd_sc_hd__inv_2
XFILLER_0_45_542 VGND VGND VPWR VPWR sky130_fd_sc_hd__decap_8
XFILLER_0_45_564 VGND VGND VPWR VPWR sky130_fd_sc_hd__decap_8
XFILLER_0_72_372 VPWR VGND VPWR VGND sky130_ef_sc_hd__decap_12
XANTENNA__4490__RESET_B tree_instances\[0\].u_tree.rst_n VGND VGND VPWR VPWR sky130_fd_sc_hd__diode_2
XFILLER_0_60_545 VGND VGND VPWR VPWR sky130_fd_sc_hd__decap_6
XFILLER_0_4_160 VGND VGND VPWR VPWR sky130_fd_sc_hd__fill_2
XFILLER_0_32_236 VGND VGND VPWR VPWR sky130_fd_sc_hd__decap_8
XFILLER_0_32_247 VGND VGND VPWR VPWR sky130_fd_sc_hd__fill_2
XFILLER_0_20_409 VGND VGND VPWR VPWR sky130_fd_sc_hd__decap_8
X_4609_ clknet_leaf_8_clk _0324_ tree_instances\[0\].u_tree.rst_n VGND VGND VPWR VPWR
+ tree_instances\[9\].u_tree.pipeline_frame_id\[0\]\[1\] sky130_fd_sc_hd__dfrtp_1
XFILLER_0_67_100 VGND VGND VPWR VPWR sky130_fd_sc_hd__decap_8
XTAP_TAPCELL_ROW_56_765 VGND VPWR sky130_fd_sc_hd__tapvpwrvgnd_1
XFILLER_0_95_431 VGND VGND VPWR VPWR sky130_fd_sc_hd__decap_3
XFILLER_0_67_133 VGND VGND VPWR VPWR sky130_fd_sc_hd__fill_2
XTAP_TAPCELL_ROW_28_489 VGND VPWR sky130_fd_sc_hd__tapvpwrvgnd_1
XFILLER_0_95_497 VGND VGND VPWR VPWR sky130_fd_sc_hd__decap_6
XFILLER_0_82_136 VGND VGND VPWR VPWR sky130_fd_sc_hd__fill_1
XANTENNA__4578__RESET_B net12 VGND VGND VPWR VPWR sky130_fd_sc_hd__diode_2
XTAP_TAPCELL_ROW_11_323 VGND VPWR sky130_fd_sc_hd__tapvpwrvgnd_1
XANTENNA__4507__RESET_B net13 VGND VGND VPWR VPWR sky130_fd_sc_hd__diode_2
XFILLER_0_36_531 VGND VGND VPWR VPWR sky130_fd_sc_hd__fill_1
XANTENNA__3198__A1 _0726_ VGND VGND VPWR VPWR sky130_fd_sc_hd__diode_2
XFILLER_0_51_545 VPWR VGND VPWR VGND sky130_ef_sc_hd__decap_12
XFILLER_0_23_258 VGND VGND VPWR VPWR sky130_fd_sc_hd__fill_1
XANTENNA__3122__A1 _0647_ VGND VGND VPWR VPWR sky130_fd_sc_hd__diode_2
XANTENNA__3122__B2 _0702_ VGND VGND VPWR VPWR sky130_fd_sc_hd__diode_2
XTAP_TAPCELL_ROW_19_401 VGND VPWR sky130_fd_sc_hd__tapvpwrvgnd_1
XFILLER_0_86_442 VPWR VGND VPWR VGND sky130_ef_sc_hd__decap_12
XFILLER_0_80_35 VGND VGND VPWR VPWR sky130_fd_sc_hd__fill_2
X_3911_ tree_instances\[12\].u_tree.pipeline_frame_id\[0\]\[4\] _1168_ _0008_ VGND
+ VGND VPWR VPWR _1308_ sky130_fd_sc_hd__mux2_1
X_4891_ clknet_leaf_26_clk _0563_ net11 VGND VGND VPWR VPWR tree_instances\[20\].u_tree.frame_id_out\[2\]
+ sky130_fd_sc_hd__dfrtp_1
XFILLER_0_80_68 VPWR VGND VPWR VGND sky130_ef_sc_hd__decap_12
X_3842_ tree_instances\[11\].u_tree.pipeline_current_node\[0\]\[8\] _1254_ VGND VGND
+ VPWR VPWR _1265_ sky130_fd_sc_hd__and2_1
XFILLER_0_58_188 VGND VGND VPWR VPWR sky130_fd_sc_hd__fill_2
XFILLER_0_46_339 VGND VGND VPWR VPWR sky130_fd_sc_hd__decap_4
XANTENNA__3189__B2 _0661_ VGND VGND VPWR VPWR sky130_fd_sc_hd__diode_2
XANTENNA__3189__A1 _0657_ VGND VGND VPWR VPWR sky130_fd_sc_hd__diode_2
XFILLER_0_6_414 VGND VGND VPWR VPWR sky130_fd_sc_hd__fill_2
XFILLER_0_6_469 VGND VGND VPWR VPWR sky130_fd_sc_hd__decap_6
XFILLER_0_42_501 VGND VGND VPWR VPWR sky130_fd_sc_hd__fill_2
X_3773_ _1228_ VGND VGND VPWR VPWR _0332_ sky130_fd_sc_hd__clkbuf_1
X_2724_ _2035_ VGND VGND VPWR VPWR _2040_ sky130_fd_sc_hd__clkbuf_1
XFILLER_0_42_545 VGND VGND VPWR VPWR sky130_fd_sc_hd__fill_1
XFILLER_0_54_383 VGND VGND VPWR VPWR sky130_fd_sc_hd__decap_3
X_2655_ _1943_ VGND VGND VPWR VPWR _1977_ sky130_fd_sc_hd__clkbuf_1
XFILLER_0_1_152 VPWR VGND VPWR VGND sky130_ef_sc_hd__decap_12
X_2586_ tree_instances\[1\].u_tree.pipeline_current_node\[0\]\[3\] VGND VGND VPWR
+ VPWR _1919_ sky130_fd_sc_hd__clkbuf_1
X_4325_ complete_votes\[1\] _0889_ complete_votes\[3\] _1545_ VGND VGND VPWR VPWR
+ _1546_ sky130_fd_sc_hd__or4_1
X_4256_ _1510_ VGND VGND VPWR VPWR _0533_ sky130_fd_sc_hd__clkbuf_1
XANTENNA__3113__B2 _0689_ VGND VGND VPWR VPWR sky130_fd_sc_hd__diode_2
X_3207_ _0660_ tree_instances\[5\].u_tree.frame_id_out\[4\] VGND VGND VPWR VPWR _0879_
+ sky130_fd_sc_hd__and2_1
X_4187_ _1474_ VGND VGND VPWR VPWR _0500_ sky130_fd_sc_hd__clkbuf_1
XFILLER_0_69_409 VPWR VGND VPWR VGND sky130_ef_sc_hd__decap_12
X_3138_ _0648_ tree_instances\[9\].u_tree.frame_id_out\[0\] tree_instances\[9\].u_tree.frame_id_out\[1\]
+ _0686_ VGND VGND VPWR VPWR _0810_ sky130_fd_sc_hd__a22o_1
XFILLER_0_49_122 VGND VGND VPWR VPWR sky130_fd_sc_hd__fill_2
X_3069_ _0694_ tree_instances\[16\].u_tree.frame_id_out\[0\] tree_instances\[16\].u_tree.frame_id_out\[1\]
+ _0685_ VGND VGND VPWR VPWR _0741_ sky130_fd_sc_hd__a2bb2o_1
XFILLER_0_92_401 VPWR VGND VPWR VGND sky130_ef_sc_hd__decap_12
XTAP_TAPCELL_ROW_81_1023 VGND VPWR sky130_fd_sc_hd__tapvpwrvgnd_1
XFILLER_0_37_306 VGND VGND VPWR VPWR sky130_fd_sc_hd__fill_2
XTAP_TAPCELL_ROW_53_735 VGND VPWR sky130_fd_sc_hd__tapvpwrvgnd_1
XTAP_TAPCELL_ROW_25_459 VGND VPWR sky130_fd_sc_hd__tapvpwrvgnd_1
XFILLER_0_18_531 VGND VGND VPWR VPWR sky130_fd_sc_hd__fill_1
XANTENNA__4600__RESET_B net9 VGND VGND VPWR VPWR sky130_fd_sc_hd__diode_2
XTAP_TAPCELL_ROW_92_1130 VGND VPWR sky130_fd_sc_hd__tapvpwrvgnd_1
XANTENNA__3205__A_N _0733_ VGND VGND VPWR VPWR sky130_fd_sc_hd__diode_2
XANTENNA_clkbuf_leaf_31_clk_A clknet_3_6__leaf_clk VGND VGND VPWR VPWR sky130_fd_sc_hd__diode_2
XFILLER_0_18_29 VGND VGND VPWR VPWR sky130_fd_sc_hd__fill_1
XANTENNA__4759__RESET_B net11 VGND VGND VPWR VPWR sky130_fd_sc_hd__diode_2
XANTENNA_clkbuf_leaf_46_clk_A clknet_3_5__leaf_clk VGND VGND VPWR VPWR sky130_fd_sc_hd__diode_2
XFILLER_0_68_475 VGND VGND VPWR VPWR sky130_fd_sc_hd__fill_1
XFILLER_0_68_486 VGND VGND VPWR VPWR sky130_fd_sc_hd__decap_4
XFILLER_0_24_501 VGND VGND VPWR VPWR sky130_fd_sc_hd__fill_1
XFILLER_0_36_361 VGND VGND VPWR VPWR sky130_fd_sc_hd__decap_3
XFILLER_0_55_169 VGND VGND VPWR VPWR sky130_fd_sc_hd__fill_1
XFILLER_0_3_417 VPWR VGND VPWR VGND sky130_ef_sc_hd__decap_12
XFILLER_0_24_545 VPWR VGND VPWR VGND sky130_ef_sc_hd__decap_12
XFILLER_0_11_217 VGND VGND VPWR VPWR sky130_fd_sc_hd__decap_6
X_2440_ tree_instances\[16\].u_tree.tree_state\[2\] _1793_ tree_instances\[16\].u_tree.tree_state\[1\]
+ VGND VGND VPWR VPWR _0057_ sky130_fd_sc_hd__a21o_1
X_2371_ tree_instances\[14\].u_tree.pipeline_current_node\[0\]\[5\] VGND VGND VPWR
+ VPWR _1732_ sky130_fd_sc_hd__clkbuf_1
X_4110_ tree_instances\[16\].u_tree.frame_id_out\[4\] tree_instances\[16\].u_tree.pipeline_frame_id\[0\]\[4\]
+ tree_instances\[16\].u_tree.tree_state\[3\] VGND VGND VPWR VPWR _1418_ sky130_fd_sc_hd__mux2_1
X_4041_ _1382_ VGND VGND VPWR VPWR _0446_ sky130_fd_sc_hd__clkbuf_1
XFILLER_0_91_34 VGND VGND VPWR VPWR sky130_fd_sc_hd__decap_6
XFILLER_0_59_431 VPWR VGND VPWR VGND sky130_ef_sc_hd__decap_12
XFILLER_0_59_453 VGND VGND VPWR VPWR sky130_fd_sc_hd__decap_8
XANTENNA__4429__RESET_B net9 VGND VGND VPWR VPWR sky130_fd_sc_hd__diode_2
XFILLER_0_74_434 VPWR VGND VPWR VGND sky130_ef_sc_hd__decap_12
XFILLER_0_19_317 VPWR VGND VPWR VGND sky130_ef_sc_hd__decap_12
XFILLER_0_46_125 VPWR VGND VPWR VGND sky130_ef_sc_hd__decap_12
XTAP_TAPCELL_ROW_50_705 VGND VPWR sky130_fd_sc_hd__tapvpwrvgnd_1
XFILLER_0_74_467 VGND VGND VPWR VPWR sky130_fd_sc_hd__decap_8
X_4874_ clknet_leaf_43_clk _0546_ net10 VGND VGND VPWR VPWR tree_instances\[16\].u_tree.pipeline_valid\[0\]
+ sky130_fd_sc_hd__dfrtp_1
XTAP_TAPCELL_ROW_22_429 VGND VPWR sky130_fd_sc_hd__tapvpwrvgnd_1
XFILLER_0_6_211 VGND VGND VPWR VPWR sky130_fd_sc_hd__fill_2
XFILLER_0_34_309 VGND VGND VPWR VPWR sky130_fd_sc_hd__decap_3
X_3825_ _2033_ _1255_ VGND VGND VPWR VPWR _1256_ sky130_fd_sc_hd__and2_1
XFILLER_0_42_320 VGND VGND VPWR VPWR sky130_fd_sc_hd__fill_2
X_3756_ tree_instances\[9\].u_tree.pipeline_frame_id\[0\]\[1\] _1124_ _0042_ VGND
+ VGND VPWR VPWR _1220_ sky130_fd_sc_hd__mux2_1
XFILLER_0_6_299 VGND VGND VPWR VPWR sky130_fd_sc_hd__decap_4
X_2707_ tree_instances\[4\].u_tree.prediction_valid VGND VGND VPWR VPWR _2025_ sky130_fd_sc_hd__inv_2
X_3687_ _1180_ VGND VGND VPWR VPWR _0294_ sky130_fd_sc_hd__clkbuf_1
XFILLER_0_71_3 VPWR VGND VPWR VGND sky130_ef_sc_hd__decap_12
XFILLER_0_30_537 VGND VGND VPWR VPWR sky130_fd_sc_hd__fill_1
X_2638_ _1961_ _1963_ VGND VGND VPWR VPWR _1964_ sky130_fd_sc_hd__or2_1
X_2569_ _1905_ VGND VGND VPWR VPWR _1906_ sky130_fd_sc_hd__clkbuf_1
X_4308_ tree_instances\[20\].u_tree.pipeline_frame_id\[0\]\[3\] _0678_ _0026_ VGND
+ VGND VPWR VPWR _1537_ sky130_fd_sc_hd__mux2_1
X_4239_ tree_instances\[19\].u_tree.tree_state\[2\] tree_instances\[19\].u_tree.tree_state\[1\]
+ _0640_ VGND VGND VPWR VPWR _1501_ sky130_fd_sc_hd__or3_1
XFILLER_0_4_93 VGND VGND VPWR VPWR sky130_fd_sc_hd__decap_8
XANTENNA__4852__RESET_B net10 VGND VGND VPWR VPWR sky130_fd_sc_hd__diode_2
XTAP_TAPCELL_ROW_66_871 VGND VPWR sky130_fd_sc_hd__tapvpwrvgnd_1
XTAP_TAPCELL_ROW_38_584 VGND VPWR sky130_fd_sc_hd__tapvpwrvgnd_1
XFILLER_0_77_294 VGND VGND VPWR VPWR sky130_fd_sc_hd__fill_1
XFILLER_0_18_361 VGND VGND VPWR VPWR sky130_fd_sc_hd__decap_3
XFILLER_0_37_169 VPWR VGND VPWR VGND sky130_ef_sc_hd__decap_12
XFILLER_0_33_353 VPWR VGND VPWR VGND sky130_ef_sc_hd__decap_12
XFILLER_0_45_27 VPWR VGND VPWR VGND sky130_ef_sc_hd__decap_12
XANTENNA__4522__RESET_B net12 VGND VGND VPWR VPWR sky130_fd_sc_hd__diode_2
XPHY_EDGE_ROW_14_Left_111 VGND VGND VPWR VPWR sky130_fd_sc_hd__decap_3
XFILLER_0_0_29 VPWR VGND VPWR VGND sky130_ef_sc_hd__decap_12
XFILLER_0_68_283 VGND VGND VPWR VPWR sky130_fd_sc_hd__fill_2
XFILLER_0_68_261 VGND VGND VPWR VPWR sky130_fd_sc_hd__fill_2
XFILLER_0_43_117 VGND VGND VPWR VPWR sky130_fd_sc_hd__fill_2
X_3610_ tree_instances\[6\].u_tree.frame_id_out\[1\] tree_instances\[6\].u_tree.pipeline_frame_id\[0\]\[1\]
+ _1750_ VGND VGND VPWR VPWR _1130_ sky130_fd_sc_hd__mux2_1
X_4590_ clknet_leaf_24_clk _0310_ net11 VGND VGND VPWR VPWR tree_instances\[8\].u_tree.frame_id_out\[2\]
+ sky130_fd_sc_hd__dfrtp_1
XFILLER_0_9_27 VPWR VGND VPWR VGND sky130_ef_sc_hd__decap_12
XFILLER_0_36_180 VGND VGND VPWR VPWR sky130_fd_sc_hd__decap_8
X_3541_ tree_instances\[5\].u_tree.frame_id_out\[0\] tree_instances\[5\].u_tree.pipeline_frame_id\[0\]\[0\]
+ _1770_ VGND VGND VPWR VPWR _1084_ sky130_fd_sc_hd__mux2_1
XFILLER_0_36_191 VGND VGND VPWR VPWR sky130_fd_sc_hd__decap_4
XFILLER_0_10_41 VPWR VGND VPWR VGND sky130_ef_sc_hd__decap_12
XPHY_EDGE_ROW_23_Left_120 VGND VGND VPWR VPWR sky130_fd_sc_hd__decap_3
XFILLER_0_51_161 VGND VGND VPWR VPWR sky130_fd_sc_hd__decap_6
XANTENNA__3316__A1 _0673_ VGND VGND VPWR VPWR sky130_fd_sc_hd__diode_2
XFILLER_0_10_85 VGND VGND VPWR VPWR sky130_fd_sc_hd__decap_3
X_3472_ tree_instances\[4\].u_tree.pipeline_frame_id\[0\]\[1\] _0673_ _0032_ VGND
+ VGND VPWR VPWR _1040_ sky130_fd_sc_hd__mux2_1
X_2423_ tree_instances\[16\].u_tree.pipeline_current_node\[0\]\[1\] VGND VGND VPWR
+ VPWR _1777_ sky130_fd_sc_hd__clkbuf_1
XFILLER_0_86_67 VGND VGND VPWR VPWR sky130_fd_sc_hd__decap_8
X_2354_ _1716_ VGND VGND VPWR VPWR _1717_ sky130_fd_sc_hd__clkbuf_1
X_2285_ tree_instances\[8\].u_tree.pipeline_current_node\[0\]\[4\] VGND VGND VPWR
+ VPWR _1656_ sky130_fd_sc_hd__clkbuf_1
XFILLER_0_79_526 VPWR VGND VPWR VGND sky130_ef_sc_hd__decap_12
X_4024_ _1373_ VGND VGND VPWR VPWR _0438_ sky130_fd_sc_hd__clkbuf_1
XANTENNA__2166__C tree_instances\[13\].u_tree.ready_for_next VGND VGND VPWR VPWR sky130_fd_sc_hd__diode_2
XTAP_TAPCELL_ROW_63_841 VGND VPWR sky130_fd_sc_hd__tapvpwrvgnd_1
XTAP_TAPCELL_ROW_35_554 VGND VPWR sky130_fd_sc_hd__tapvpwrvgnd_1
XFILLER_0_19_125 VPWR VGND VPWR VGND sky130_ef_sc_hd__decap_12
XFILLER_0_47_434 VGND VGND VPWR VPWR sky130_fd_sc_hd__decap_3
XFILLER_0_74_253 VGND VGND VPWR VPWR sky130_fd_sc_hd__fill_2
X_4857_ clknet_leaf_28_clk _0538_ net13 VGND VGND VPWR VPWR tree_instances\[19\].u_tree.pipeline_frame_id\[0\]\[3\]
+ sky130_fd_sc_hd__dfrtp_1
XFILLER_0_62_415 VGND VGND VPWR VPWR sky130_fd_sc_hd__fill_2
XFILLER_0_19_169 VPWR VGND VPWR VGND sky130_ef_sc_hd__decap_12
XFILLER_0_7_553 VGND VGND VPWR VPWR sky130_fd_sc_hd__decap_6
X_3808_ tree_instances\[10\].u_tree.frame_id_out\[0\] tree_instances\[10\].u_tree.pipeline_frame_id\[0\]\[0\]
+ _1597_ VGND VGND VPWR VPWR _1247_ sky130_fd_sc_hd__mux2_1
X_4788_ clknet_leaf_44_clk _0476_ net13 VGND VGND VPWR VPWR tree_instances\[16\].u_tree.frame_id_out\[0\]
+ sky130_fd_sc_hd__dfrtp_1
XFILLER_0_15_375 VGND VGND VPWR VPWR sky130_fd_sc_hd__fill_2
X_3739_ _1211_ VGND VGND VPWR VPWR _0315_ sky130_fd_sc_hd__clkbuf_1
XFILLER_0_42_150 VPWR VGND VPWR VGND sky130_ef_sc_hd__decap_12
XTAP_TAPCELL_ROW_7_279 VGND VPWR sky130_fd_sc_hd__tapvpwrvgnd_1
XFILLER_0_85_518 VGND VGND VPWR VPWR sky130_fd_sc_hd__decap_4
XFILLER_0_93_573 VGND VGND VPWR VPWR sky130_fd_sc_hd__fill_1
XFILLER_0_25_139 VGND VGND VPWR VPWR sky130_fd_sc_hd__fill_2
XFILLER_0_80_245 VGND VGND VPWR VPWR sky130_fd_sc_hd__decap_6
XFILLER_0_21_301 VGND VGND VPWR VPWR sky130_fd_sc_hd__fill_2
XFILLER_0_40_109 VPWR VGND VPWR VGND sky130_ef_sc_hd__decap_12
XFILLER_0_21_334 VGND VGND VPWR VPWR sky130_fd_sc_hd__fill_2
XFILLER_0_33_183 VGND VGND VPWR VPWR sky130_fd_sc_hd__fill_2
XANTENNA__2548__A _1666_ VGND VGND VPWR VPWR sky130_fd_sc_hd__diode_2
XANTENNA__4774__RESET_B net13 VGND VGND VPWR VPWR sky130_fd_sc_hd__diode_2
XANTENNA__4703__RESET_B net9 VGND VGND VPWR VPWR sky130_fd_sc_hd__diode_2
XTAP_TAPCELL_ROW_77_977 VGND VPWR sky130_fd_sc_hd__tapvpwrvgnd_1
XFILLER_0_88_378 VGND VGND VPWR VPWR sky130_fd_sc_hd__decap_8
XTAP_TAPCELL_ROW_60_811 VGND VPWR sky130_fd_sc_hd__tapvpwrvgnd_1
XFILLER_0_8_317 VGND VGND VPWR VPWR sky130_fd_sc_hd__fill_2
XFILLER_0_8_306 VGND VGND VPWR VPWR sky130_fd_sc_hd__fill_2
X_2972_ _0652_ VGND VGND VPWR VPWR _0107_ sky130_fd_sc_hd__clkbuf_1
XFILLER_0_84_573 VGND VGND VPWR VPWR sky130_fd_sc_hd__fill_1
XFILLER_0_16_106 VGND VGND VPWR VPWR sky130_fd_sc_hd__fill_1
XFILLER_0_29_489 VGND VGND VPWR VPWR sky130_fd_sc_hd__fill_1
XTAP_TAPCELL_ROW_32_524 VGND VPWR sky130_fd_sc_hd__tapvpwrvgnd_1
X_4711_ clknet_leaf_5_clk _0414_ net9 VGND VGND VPWR VPWR tree_instances\[13\].u_tree.frame_id_out\[1\]
+ sky130_fd_sc_hd__dfrtp_1
XFILLER_0_56_253 VGND VGND VPWR VPWR sky130_fd_sc_hd__fill_1
XFILLER_0_71_223 VGND VGND VPWR VPWR sky130_fd_sc_hd__fill_1
XFILLER_0_4_501 VPWR VGND VPWR VGND sky130_ef_sc_hd__decap_12
X_4642_ clknet_leaf_4_clk _0352_ tree_instances\[0\].u_tree.rst_n VGND VGND VPWR VPWR
+ tree_instances\[10\].u_tree.frame_id_out\[3\] sky130_fd_sc_hd__dfrtp_1
XANTENNA__3537__A1 _0925_ VGND VGND VPWR VPWR sky130_fd_sc_hd__diode_2
XFILLER_0_21_73 VGND VGND VPWR VPWR sky130_fd_sc_hd__decap_3
XFILLER_0_4_545 VPWR VGND VPWR VGND sky130_ef_sc_hd__decap_12
X_4573_ clknet_leaf_62_clk _0103_ net9 VGND VGND VPWR VPWR tree_instances\[7\].u_tree.prediction_valid
+ sky130_fd_sc_hd__dfrtp_1
XFILLER_0_12_323 VGND VGND VPWR VPWR sky130_fd_sc_hd__fill_2
X_3524_ _1074_ VGND VGND VPWR VPWR _1075_ sky130_fd_sc_hd__clkbuf_1
X_3455_ _1031_ VGND VGND VPWR VPWR _0211_ sky130_fd_sc_hd__clkbuf_1
X_2406_ _1758_ _1762_ VGND VGND VPWR VPWR _1763_ sky130_fd_sc_hd__or2_1
X_3386_ tree_instances\[2\].u_tree.frame_id_out\[2\] tree_instances\[2\].u_tree.pipeline_frame_id\[0\]\[2\]
+ _1891_ VGND VGND VPWR VPWR _0990_ sky130_fd_sc_hd__mux2_1
X_2337_ _1700_ VGND VGND VPWR VPWR _1701_ sky130_fd_sc_hd__clkbuf_1
X_2268_ _1640_ _1642_ VGND VGND VPWR VPWR _1643_ sky130_fd_sc_hd__nor2_1
XTAP_TAPCELL_ROW_4_249 VGND VPWR sky130_fd_sc_hd__tapvpwrvgnd_1
XANTENNA__4444__RESET_B net9 VGND VGND VPWR VPWR sky130_fd_sc_hd__diode_2
X_4007_ tree_instances\[14\].u_tree.pipeline_frame_id\[0\]\[1\] _0672_ _0012_ VGND
+ VGND VPWR VPWR _1365_ sky130_fd_sc_hd__mux2_1
X_2199_ tree_instances\[12\].u_tree.tree_state\[0\] _1578_ _1579_ VGND VGND VPWR VPWR
+ _0048_ sky130_fd_sc_hd__a21o_1
XTAP_TAPCELL_ROW_48_690 VGND VPWR sky130_fd_sc_hd__tapvpwrvgnd_1
XFILLER_0_79_389 VGND VGND VPWR VPWR sky130_fd_sc_hd__fill_1
XFILLER_0_39_209 VGND VGND VPWR VPWR sky130_fd_sc_hd__fill_2
XFILLER_0_94_348 VGND VGND VPWR VPWR sky130_fd_sc_hd__fill_2
XANTENNA__2193__A _1574_ VGND VGND VPWR VPWR sky130_fd_sc_hd__diode_2
XFILLER_0_62_80 VGND VGND VPWR VPWR sky130_fd_sc_hd__decap_4
XFILLER_0_75_573 VGND VGND VPWR VPWR sky130_fd_sc_hd__fill_1
XFILLER_0_62_289 VPWR VGND VPWR VGND sky130_ef_sc_hd__decap_12
XFILLER_0_22_109 VGND VGND VPWR VPWR sky130_fd_sc_hd__decap_8
XFILLER_0_43_481 VGND VGND VPWR VPWR sky130_fd_sc_hd__fill_2
XFILLER_0_30_131 VGND VGND VPWR VPWR sky130_fd_sc_hd__decap_8
XFILLER_0_30_186 VGND VGND VPWR VPWR sky130_fd_sc_hd__decap_3
XFILLER_0_30_197 VGND VGND VPWR VPWR sky130_fd_sc_hd__decap_8
XTAP_TAPCELL_ROW_89_1102 VGND VPWR sky130_fd_sc_hd__tapvpwrvgnd_1
XFILLER_0_26_29 VPWR VGND VPWR VGND sky130_ef_sc_hd__decap_12
XTAP_TAPCELL_ROW_74_947 VGND VPWR sky130_fd_sc_hd__tapvpwrvgnd_1
XFILLER_0_85_337 VGND VGND VPWR VPWR sky130_fd_sc_hd__fill_2
XFILLER_0_66_551 VGND VGND VPWR VPWR sky130_fd_sc_hd__fill_1
XFILLER_0_38_253 VGND VGND VPWR VPWR sky130_fd_sc_hd__decap_8
XFILLER_0_38_264 VPWR VGND VPWR VGND sky130_ef_sc_hd__decap_12
XFILLER_0_1_559 VGND VGND VPWR VPWR sky130_fd_sc_hd__fill_1
XFILLER_0_21_197 VGND VGND VPWR VPWR sky130_fd_sc_hd__fill_2
XANTENNA__4715__SET_B net9 VGND VGND VPWR VPWR sky130_fd_sc_hd__diode_2
XANTENNA__3662__A _0674_ VGND VGND VPWR VPWR sky130_fd_sc_hd__diode_2
X_3240_ _0686_ _0649_ VGND VGND VPWR VPWR _0122_ sky130_fd_sc_hd__xnor2_1
X_3171_ _0827_ _0833_ _0842_ VGND VGND VPWR VPWR _0843_ sky130_fd_sc_hd__a21o_1
XFILLER_0_83_57 VPWR VGND VPWR VGND sky130_ef_sc_hd__decap_12
XTAP_TAPCELL_ROW_1_219 VGND VPWR sky130_fd_sc_hd__tapvpwrvgnd_1
XFILLER_0_76_304 VGND VGND VPWR VPWR sky130_fd_sc_hd__decap_4
XFILLER_0_16_73 VGND VGND VPWR VPWR sky130_fd_sc_hd__fill_1
XFILLER_0_88_197 VGND VGND VPWR VPWR sky130_fd_sc_hd__fill_1
XFILLER_0_29_220 VGND VGND VPWR VPWR sky130_fd_sc_hd__decap_4
XTAP_TAPCELL_ROW_45_660 VGND VPWR sky130_fd_sc_hd__tapvpwrvgnd_1
XFILLER_0_57_573 VGND VGND VPWR VPWR sky130_fd_sc_hd__fill_1
XANTENNA__3758__A1 _1165_ VGND VGND VPWR VPWR sky130_fd_sc_hd__diode_2
X_2955_ _0639_ _1969_ VGND VGND VPWR VPWR _0640_ sky130_fd_sc_hd__or2_1
XFILLER_0_8_158 VGND VGND VPWR VPWR sky130_fd_sc_hd__fill_1
XFILLER_0_17_426 VGND VGND VPWR VPWR sky130_fd_sc_hd__fill_1
XFILLER_0_29_275 VGND VGND VPWR VPWR sky130_fd_sc_hd__decap_4
XFILLER_0_44_223 VGND VGND VPWR VPWR sky130_fd_sc_hd__fill_2
X_2886_ tree_instances\[10\].u_tree.pipeline_current_node\[0\]\[6\] VGND VGND VPWR
+ VPWR _0593_ sky130_fd_sc_hd__clkbuf_1
XFILLER_0_44_234 VGND VGND VPWR VPWR sky130_fd_sc_hd__fill_2
X_4625_ clknet_leaf_2_clk _0335_ net9 VGND VGND VPWR VPWR tree_instances\[10\].u_tree.pipeline_current_node\[0\]\[0\]
+ sky130_fd_sc_hd__dfrtp_1
XFILLER_0_12_120 VGND VGND VPWR VPWR sky130_fd_sc_hd__fill_2
X_4556_ clknet_leaf_65_clk _0277_ net9 VGND VGND VPWR VPWR tree_instances\[7\].u_tree.pipeline_current_node\[0\]\[3\]
+ sky130_fd_sc_hd__dfrtp_1
X_3507_ _1061_ VGND VGND VPWR VPWR _1062_ sky130_fd_sc_hd__clkbuf_1
XFILLER_0_4_397 VPWR VGND VPWR VGND sky130_ef_sc_hd__decap_12
XANTENNA__4696__RESET_B net9 VGND VGND VPWR VPWR sky130_fd_sc_hd__diode_2
XFILLER_0_40_473 VGND VGND VPWR VPWR sky130_fd_sc_hd__fill_1
XFILLER_0_12_197 VPWR VGND VPWR VGND sky130_ef_sc_hd__decap_12
X_4487_ clknet_leaf_61_clk _0227_ tree_instances\[0\].u_tree.rst_n VGND VGND VPWR
+ VPWR tree_instances\[4\].u_tree.frame_id_out\[3\] sky130_fd_sc_hd__dfrtp_1
X_3438_ _1584_ VGND VGND VPWR VPWR _1017_ sky130_fd_sc_hd__clkbuf_1
XANTENNA__4625__RESET_B net9 VGND VGND VPWR VPWR sky130_fd_sc_hd__diode_2
X_3369_ _0981_ VGND VGND VPWR VPWR _0175_ sky130_fd_sc_hd__clkbuf_1
XFILLER_0_79_164 VGND VGND VPWR VPWR sky130_fd_sc_hd__decap_4
XTAP_TAPCELL_ROW_71_917 VGND VPWR sky130_fd_sc_hd__tapvpwrvgnd_1
XFILLER_0_67_337 VGND VGND VPWR VPWR sky130_fd_sc_hd__decap_8
XFILLER_0_82_307 VGND VGND VPWR VPWR sky130_fd_sc_hd__fill_1
XFILLER_0_90_373 VGND VGND VPWR VPWR sky130_fd_sc_hd__fill_1
XFILLER_0_35_278 VGND VGND VPWR VPWR sky130_fd_sc_hd__fill_2
XANTENNA__4174__A1 _0674_ VGND VGND VPWR VPWR sky130_fd_sc_hd__diode_2
XFILLER_0_50_248 VGND VGND VPWR VPWR sky130_fd_sc_hd__fill_1
XTAP_TAPCELL_ROW_95_1161 VGND VPWR sky130_fd_sc_hd__tapvpwrvgnd_1
Xoutput7 net7 VGND VGND VPWR VPWR prediction_valid sky130_fd_sc_hd__buf_8
XTAP_TAPCELL_ROW_59_796 VGND VPWR sky130_fd_sc_hd__tapvpwrvgnd_1
XFILLER_0_58_304 VGND VGND VPWR VPWR sky130_fd_sc_hd__decap_4
XFILLER_0_58_348 VGND VGND VPWR VPWR sky130_fd_sc_hd__fill_2
XFILLER_0_73_318 VGND VGND VPWR VPWR sky130_fd_sc_hd__fill_1
XTAP_TAPCELL_ROW_42_630 VGND VPWR sky130_fd_sc_hd__tapvpwrvgnd_1
XANTENNA__3657__A _0664_ VGND VGND VPWR VPWR sky130_fd_sc_hd__diode_2
X_2740_ _2049_ VGND VGND VPWR VPWR _2051_ sky130_fd_sc_hd__clkbuf_1
XFILLER_0_26_223 VGND VGND VPWR VPWR sky130_fd_sc_hd__fill_1
X_2671_ _1988_ VGND VGND VPWR VPWR _1993_ sky130_fd_sc_hd__clkbuf_1
X_4410_ clknet_leaf_22_clk _0157_ net11 VGND VGND VPWR VPWR tree_instances\[1\].u_tree.pipeline_frame_id\[0\]\[1\]
+ sky130_fd_sc_hd__dfrtp_1
XFILLER_0_78_79 VGND VGND VPWR VPWR sky130_fd_sc_hd__decap_4
X_4341_ clknet_leaf_12_clk _0046_ tree_instances\[0\].u_tree.rst_n VGND VGND VPWR
+ VPWR tree_instances\[11\].u_tree.tree_state\[0\] sky130_fd_sc_hd__dfstp_1
X_4272_ _1518_ VGND VGND VPWR VPWR _0541_ sky130_fd_sc_hd__clkbuf_1
XFILLER_0_1_389 VGND VGND VPWR VPWR sky130_fd_sc_hd__decap_3
X_3223_ complete_votes\[1\] complete_votes\[0\] VGND VGND VPWR VPWR _0893_ sky130_fd_sc_hd__nand2_1
XPHY_EDGE_ROW_6_Left_103 VGND VGND VPWR VPWR sky130_fd_sc_hd__decap_3
X_3154_ tree_instances\[10\].u_tree.frame_id_out\[2\] VGND VGND VPWR VPWR _0826_ sky130_fd_sc_hd__inv_2
X_3085_ tree_instances\[18\].u_tree.frame_id_out\[3\] VGND VGND VPWR VPWR _0757_ sky130_fd_sc_hd__inv_2
XFILLER_0_89_484 VGND VGND VPWR VPWR sky130_fd_sc_hd__fill_2
XFILLER_0_49_337 VGND VGND VPWR VPWR sky130_fd_sc_hd__fill_2
XFILLER_0_76_145 VGND VGND VPWR VPWR sky130_fd_sc_hd__decap_8
X_3987_ _1287_ _1354_ VGND VGND VPWR VPWR _1355_ sky130_fd_sc_hd__and2_1
XFILLER_0_17_245 VGND VGND VPWR VPWR sky130_fd_sc_hd__fill_1
X_2938_ _0628_ VGND VGND VPWR VPWR _0017_ sky130_fd_sc_hd__clkbuf_1
XANTENNA__4877__RESET_B net10 VGND VGND VPWR VPWR sky130_fd_sc_hd__diode_2
X_2869_ _2160_ VGND VGND VPWR VPWR _0576_ sky130_fd_sc_hd__clkbuf_1
XFILLER_0_72_384 VGND VGND VPWR VPWR sky130_fd_sc_hd__decap_8
XANTENNA__4806__RESET_B net13 VGND VGND VPWR VPWR sky130_fd_sc_hd__diode_2
XFILLER_0_4_194 VGND VGND VPWR VPWR sky130_fd_sc_hd__fill_2
X_4608_ clknet_leaf_8_clk _0323_ net12 VGND VGND VPWR VPWR tree_instances\[9\].u_tree.pipeline_frame_id\[0\]\[0\]
+ sky130_fd_sc_hd__dfrtp_1
X_4539_ clknet_leaf_20_clk _0269_ net11 VGND VGND VPWR VPWR tree_instances\[6\].u_tree.frame_id_out\[2\]
+ sky130_fd_sc_hd__dfrtp_1
XANTENNA__3903__A1 _1162_ VGND VGND VPWR VPWR sky130_fd_sc_hd__diode_2
XFILLER_0_13_484 VPWR VGND VPWR VGND sky130_ef_sc_hd__decap_12
XFILLER_0_40_281 VPWR VGND VPWR VGND sky130_ef_sc_hd__decap_12
XTAP_TAPCELL_ROW_56_766 VGND VPWR sky130_fd_sc_hd__tapvpwrvgnd_1
Xclkbuf_3_6__f_clk clknet_0_clk VGND VGND VPWR VPWR clknet_3_6__leaf_clk sky130_fd_sc_hd__clkbuf_16
XFILLER_0_23_19 VPWR VGND VPWR VGND sky130_ef_sc_hd__decap_12
XFILLER_0_67_167 VGND VGND VPWR VPWR sky130_fd_sc_hd__fill_1
XFILLER_0_82_126 VGND VGND VPWR VPWR sky130_fd_sc_hd__fill_2
XFILLER_0_63_373 VGND VGND VPWR VPWR sky130_fd_sc_hd__fill_2
XFILLER_0_23_204 VGND VGND VPWR VPWR sky130_fd_sc_hd__fill_2
XFILLER_0_2_109 VPWR VGND VPWR VGND sky130_ef_sc_hd__decap_12
XANTENNA__4547__RESET_B net12 VGND VGND VPWR VPWR sky130_fd_sc_hd__diode_2
XANTENNA_clkbuf_leaf_5_clk_A clknet_3_0__leaf_clk VGND VGND VPWR VPWR sky130_fd_sc_hd__diode_2
XFILLER_0_51_557 VGND VGND VPWR VPWR sky130_fd_sc_hd__decap_3
XFILLER_0_31_281 VGND VGND VPWR VPWR sky130_fd_sc_hd__decap_4
XFILLER_0_48_27 VGND VGND VPWR VPWR sky130_fd_sc_hd__fill_1
XPHY_EDGE_ROW_79_Left_176 VGND VGND VPWR VPWR sky130_fd_sc_hd__decap_3
XFILLER_0_64_15 VGND VGND VPWR VPWR sky130_fd_sc_hd__fill_2
XFILLER_0_3_29 VGND VGND VPWR VPWR sky130_fd_sc_hd__fill_2
XTAP_TAPCELL_ROW_19_402 VGND VPWR sky130_fd_sc_hd__tapvpwrvgnd_1
XFILLER_0_86_410 VGND VGND VPWR VPWR sky130_fd_sc_hd__decap_8
XFILLER_0_86_421 VGND VGND VPWR VPWR sky130_fd_sc_hd__decap_3
XFILLER_0_86_465 VGND VGND VPWR VPWR sky130_fd_sc_hd__fill_1
XFILLER_0_86_454 VGND VGND VPWR VPWR sky130_fd_sc_hd__decap_8
X_3910_ _1307_ VGND VGND VPWR VPWR _0390_ sky130_fd_sc_hd__clkbuf_1
XFILLER_0_46_307 VGND VGND VPWR VPWR sky130_fd_sc_hd__fill_1
X_4890_ clknet_leaf_26_clk _0562_ net12 VGND VGND VPWR VPWR tree_instances\[20\].u_tree.frame_id_out\[1\]
+ sky130_fd_sc_hd__dfrtp_1
XPHY_EDGE_ROW_88_Left_185 VGND VGND VPWR VPWR sky130_fd_sc_hd__decap_3
XFILLER_0_73_126 VPWR VGND VPWR VGND sky130_ef_sc_hd__decap_12
X_3841_ _1264_ VGND VGND VPWR VPWR _0364_ sky130_fd_sc_hd__clkbuf_1
X_3772_ tree_instances\[9\].u_tree.frame_id_out\[4\] tree_instances\[9\].u_tree.pipeline_frame_id\[0\]\[4\]
+ tree_instances\[9\].u_tree.tree_state\[3\] VGND VGND VPWR VPWR _1228_ sky130_fd_sc_hd__mux2_1
X_2723_ _2034_ VGND VGND VPWR VPWR _2039_ sky130_fd_sc_hd__clkbuf_1
XFILLER_0_89_67 VGND VGND VPWR VPWR sky130_fd_sc_hd__decap_8
X_2654_ _1974_ VGND VGND VPWR VPWR _1976_ sky130_fd_sc_hd__clkbuf_1
XFILLER_0_14_248 VGND VGND VPWR VPWR sky130_fd_sc_hd__decap_4
XFILLER_0_42_568 VGND VGND VPWR VPWR sky130_fd_sc_hd__decap_6
X_2585_ tree_instances\[1\].u_tree.pipeline_current_node\[0\]\[2\] VGND VGND VPWR
+ VPWR _1918_ sky130_fd_sc_hd__clkbuf_1
X_4324_ complete_votes\[2\] complete_votes\[4\] VGND VGND VPWR VPWR _1545_ sky130_fd_sc_hd__nand2_1
XFILLER_0_10_421 VGND VGND VPWR VPWR sky130_fd_sc_hd__decap_3
XFILLER_0_1_164 VGND VGND VPWR VPWR sky130_fd_sc_hd__decap_4
XANTENNA__4368__D _0042_ VGND VGND VPWR VPWR sky130_fd_sc_hd__diode_2
X_4255_ tree_instances\[19\].u_tree.pipeline_current_node\[0\]\[7\] _1501_ VGND VGND
+ VPWR VPWR _1510_ sky130_fd_sc_hd__and2_1
XANTENNA__2169__C tree_instances\[17\].u_tree.ready_for_next VGND VGND VPWR VPWR sky130_fd_sc_hd__diode_2
XANTENNA__4310__A1 tree_instances\[0\].u_tree.frame_id_in\[4\] VGND VGND VPWR VPWR
+ sky130_fd_sc_hd__diode_2
X_3206_ _0702_ tree_instances\[5\].u_tree.frame_id_out\[3\] _0876_ _0877_ VGND VGND
+ VPWR VPWR _0878_ sky130_fd_sc_hd__a211oi_1
X_4186_ tree_instances\[17\].u_tree.frame_id_out\[3\] tree_instances\[17\].u_tree.pipeline_frame_id\[0\]\[3\]
+ _1827_ VGND VGND VPWR VPWR _1474_ sky130_fd_sc_hd__mux2_1
X_3137_ _0772_ _0782_ _0791_ _0808_ VGND VGND VPWR VPWR _0809_ sky130_fd_sc_hd__and4b_1
XFILLER_0_89_281 VGND VGND VPWR VPWR sky130_fd_sc_hd__decap_6
XFILLER_0_49_101 VGND VGND VPWR VPWR sky130_fd_sc_hd__decap_8
X_3068_ _0722_ _0729_ _0739_ VGND VGND VPWR VPWR _0740_ sky130_fd_sc_hd__a21o_1
XTAP_TAPCELL_ROW_53_736 VGND VPWR sky130_fd_sc_hd__tapvpwrvgnd_1
XFILLER_0_33_502 VGND VGND VPWR VPWR sky130_fd_sc_hd__fill_2
XFILLER_0_60_365 VPWR VGND VPWR VGND sky130_ef_sc_hd__decap_12
XANTENNA__4640__RESET_B tree_instances\[0\].u_tree.rst_n VGND VGND VPWR VPWR sky130_fd_sc_hd__diode_2
XFILLER_0_13_270 VGND VGND VPWR VPWR sky130_fd_sc_hd__decap_8
XTAP_TAPCELL_ROW_92_1131 VGND VPWR sky130_fd_sc_hd__tapvpwrvgnd_1
XFILLER_0_13_281 VPWR VGND VPWR VGND sky130_ef_sc_hd__decap_12
XANTENNA__3104__A2 _0694_ VGND VGND VPWR VPWR sky130_fd_sc_hd__diode_2
XFILLER_0_87_229 VPWR VGND VPWR VGND sky130_ef_sc_hd__decap_12
XFILLER_0_68_421 VGND VGND VPWR VPWR sky130_fd_sc_hd__decap_6
XFILLER_0_34_29 VPWR VGND VPWR VGND sky130_ef_sc_hd__decap_12
XFILLER_0_95_251 VGND VGND VPWR VPWR sky130_fd_sc_hd__fill_1
XANTENNA__4799__RESET_B tree_instances\[0\].u_tree.rst_n VGND VGND VPWR VPWR sky130_fd_sc_hd__diode_2
XANTENNA__4728__RESET_B net10 VGND VGND VPWR VPWR sky130_fd_sc_hd__diode_2
XANTENNA__3000__A _0674_ VGND VGND VPWR VPWR sky130_fd_sc_hd__diode_2
XFILLER_0_70_129 VGND VGND VPWR VPWR sky130_fd_sc_hd__fill_2
XFILLER_0_36_373 VGND VGND VPWR VPWR sky130_fd_sc_hd__fill_2
XANTENNA__4381__RESET_B net10 VGND VGND VPWR VPWR sky130_fd_sc_hd__diode_2
XFILLER_0_3_429 VPWR VGND VPWR VGND sky130_ef_sc_hd__decap_12
XFILLER_0_24_557 VPWR VGND VPWR VGND sky130_ef_sc_hd__decap_12
XFILLER_0_51_387 VGND VGND VPWR VPWR sky130_fd_sc_hd__fill_2
X_2370_ _1731_ VGND VGND VPWR VPWR _0056_ sky130_fd_sc_hd__clkbuf_1
XANTENNA__2985__S _0645_ VGND VGND VPWR VPWR sky130_fd_sc_hd__diode_2
XFILLER_0_75_14 VGND VGND VPWR VPWR sky130_fd_sc_hd__fill_2
X_4040_ _1324_ _1376_ VGND VGND VPWR VPWR _1382_ sky130_fd_sc_hd__and2_1
XFILLER_0_91_57 VPWR VGND VPWR VGND sky130_ef_sc_hd__decap_12
XFILLER_0_91_46 VGND VGND VPWR VPWR sky130_fd_sc_hd__decap_8
XFILLER_0_59_443 VGND VGND VPWR VPWR sky130_fd_sc_hd__decap_4
XFILLER_0_86_262 VGND VGND VPWR VPWR sky130_fd_sc_hd__fill_2
XFILLER_0_19_329 VGND VGND VPWR VPWR sky130_fd_sc_hd__decap_6
XTAP_TAPCELL_ROW_50_706 VGND VPWR sky130_fd_sc_hd__tapvpwrvgnd_1
XFILLER_0_74_446 VGND VGND VPWR VPWR sky130_fd_sc_hd__decap_6
XANTENNA__4469__RESET_B net9 VGND VGND VPWR VPWR sky130_fd_sc_hd__diode_2
XFILLER_0_46_137 VGND VGND VPWR VPWR sky130_fd_sc_hd__decap_3
X_4873_ clknet_leaf_42_clk _0057_ net10 VGND VGND VPWR VPWR tree_instances\[16\].u_tree.tree_state\[3\]
+ sky130_fd_sc_hd__dfrtp_1
X_3824_ _1254_ VGND VGND VPWR VPWR _1255_ sky130_fd_sc_hd__dlymetal6s2s_1
XFILLER_0_61_107 VGND VGND VPWR VPWR sky130_fd_sc_hd__fill_2
XFILLER_0_61_129 VGND VGND VPWR VPWR sky130_fd_sc_hd__fill_2
XFILLER_0_27_373 VGND VGND VPWR VPWR sky130_fd_sc_hd__fill_1
XFILLER_0_40_72 VPWR VGND VPWR VGND sky130_ef_sc_hd__decap_12
X_3755_ _1219_ VGND VGND VPWR VPWR _0323_ sky130_fd_sc_hd__clkbuf_1
X_3686_ _2087_ _1179_ VGND VGND VPWR VPWR _1180_ sky130_fd_sc_hd__and2_1
X_2706_ _2024_ VGND VGND VPWR VPWR _0099_ sky130_fd_sc_hd__clkbuf_1
XPHY_EDGE_ROW_12_Right_12 VGND VGND VPWR VPWR sky130_fd_sc_hd__decap_3
X_2637_ _1962_ VGND VGND VPWR VPWR _1963_ sky130_fd_sc_hd__clkbuf_1
XFILLER_0_10_251 VGND VGND VPWR VPWR sky130_fd_sc_hd__fill_1
X_2568_ tree_instances\[4\].u_tree.pipeline_current_node\[0\]\[0\] VGND VGND VPWR
+ VPWR _1905_ sky130_fd_sc_hd__clkbuf_1
X_4307_ _1536_ VGND VGND VPWR VPWR _0558_ sky130_fd_sc_hd__clkbuf_1
X_2499_ _1844_ VGND VGND VPWR VPWR _1845_ sky130_fd_sc_hd__clkbuf_1
X_4238_ _1970_ _1500_ _0022_ tree_instances\[19\].u_tree.pipeline_valid\[0\] VGND
+ VGND VPWR VPWR _0525_ sky130_fd_sc_hd__o2bb2a_1
XANTENNA__3098__A1 _0733_ VGND VGND VPWR VPWR sky130_fd_sc_hd__diode_2
XANTENNA__3098__B2 _0690_ VGND VGND VPWR VPWR sky130_fd_sc_hd__diode_2
XFILLER_0_4_83 VGND VGND VPWR VPWR sky130_fd_sc_hd__fill_1
X_4169_ _1465_ VGND VGND VPWR VPWR _0491_ sky130_fd_sc_hd__clkbuf_1
XTAP_TAPCELL_ROW_66_872 VGND VPWR sky130_fd_sc_hd__tapvpwrvgnd_1
XPHY_EDGE_ROW_21_Right_21 VGND VGND VPWR VPWR sky130_fd_sc_hd__decap_3
XTAP_TAPCELL_ROW_38_585 VGND VPWR sky130_fd_sc_hd__tapvpwrvgnd_1
XFILLER_0_65_424 VPWR VGND VPWR VGND sky130_ef_sc_hd__decap_12
XANTENNA__4892__RESET_B net11 VGND VGND VPWR VPWR sky130_fd_sc_hd__diode_2
XANTENNA__4821__RESET_B net11 VGND VGND VPWR VPWR sky130_fd_sc_hd__diode_2
XFILLER_0_37_148 VGND VGND VPWR VPWR sky130_fd_sc_hd__decap_8
XFILLER_0_92_265 VGND VGND VPWR VPWR sky130_fd_sc_hd__decap_4
XPHY_EDGE_ROW_30_Right_30 VGND VGND VPWR VPWR sky130_fd_sc_hd__decap_3
XFILLER_0_60_151 VGND VGND VPWR VPWR sky130_fd_sc_hd__fill_1
XFILLER_0_33_365 VGND VGND VPWR VPWR sky130_fd_sc_hd__fill_2
XFILLER_0_33_387 VGND VGND VPWR VPWR sky130_fd_sc_hd__fill_2
XFILLER_0_60_195 VGND VGND VPWR VPWR sky130_fd_sc_hd__fill_1
XANTENNA__3089__B2 _0657_ VGND VGND VPWR VPWR sky130_fd_sc_hd__diode_2
XFILLER_0_45_39 VPWR VGND VPWR VGND sky130_ef_sc_hd__decap_12
XFILLER_0_28_137 VGND VGND VPWR VPWR sky130_fd_sc_hd__decap_3
XFILLER_0_83_254 VPWR VGND VPWR VGND sky130_ef_sc_hd__decap_12
XANTENNA__4562__RESET_B tree_instances\[0\].u_tree.rst_n VGND VGND VPWR VPWR sky130_fd_sc_hd__diode_2
XFILLER_0_71_427 VGND VGND VPWR VPWR sky130_fd_sc_hd__decap_8
XFILLER_0_9_39 VPWR VGND VPWR VGND sky130_ef_sc_hd__decap_12
XFILLER_0_24_321 VPWR VGND VPWR VGND sky130_ef_sc_hd__decap_12
X_3540_ _1083_ VGND VGND VPWR VPWR _0244_ sky130_fd_sc_hd__clkbuf_1
XFILLER_0_10_53 VPWR VGND VPWR VGND sky130_ef_sc_hd__decap_12
XFILLER_0_3_259 VPWR VGND VPWR VGND sky130_ef_sc_hd__decap_12
XFILLER_0_24_365 VGND VGND VPWR VPWR sky130_fd_sc_hd__fill_2
X_3471_ _1039_ VGND VGND VPWR VPWR _0219_ sky130_fd_sc_hd__clkbuf_1
XFILLER_0_51_195 VGND VGND VPWR VPWR sky130_fd_sc_hd__fill_1
X_2422_ _1774_ _1775_ VGND VGND VPWR VPWR _1776_ sky130_fd_sc_hd__nor2_1
X_2353_ tree_instances\[13\].u_tree.pipeline_current_node\[0\]\[2\] VGND VGND VPWR
+ VPWR _1716_ sky130_fd_sc_hd__clkbuf_1
X_2284_ _1654_ VGND VGND VPWR VPWR _1655_ sky130_fd_sc_hd__clkbuf_1
X_4023_ tree_instances\[14\].u_tree.frame_id_out\[4\] tree_instances\[14\].u_tree.pipeline_frame_id\[0\]\[4\]
+ tree_instances\[14\].u_tree.tree_state\[3\] VGND VGND VPWR VPWR _1373_ sky130_fd_sc_hd__mux2_1
XFILLER_0_79_505 VGND VGND VPWR VPWR sky130_fd_sc_hd__fill_1
XFILLER_0_79_538 VGND VGND VPWR VPWR sky130_fd_sc_hd__fill_1
XTAP_TAPCELL_ROW_63_842 VGND VPWR sky130_fd_sc_hd__tapvpwrvgnd_1
XTAP_TAPCELL_ROW_35_555 VGND VPWR sky130_fd_sc_hd__tapvpwrvgnd_1
XFILLER_0_47_402 VGND VGND VPWR VPWR sky130_fd_sc_hd__fill_2
XFILLER_0_59_284 VGND VGND VPWR VPWR sky130_fd_sc_hd__fill_2
XFILLER_0_19_137 VPWR VGND VPWR VGND sky130_ef_sc_hd__decap_12
XFILLER_0_47_446 VGND VGND VPWR VPWR sky130_fd_sc_hd__fill_2
XFILLER_0_74_243 VGND VGND VPWR VPWR sky130_fd_sc_hd__decap_6
X_4856_ clknet_leaf_28_clk _0537_ net13 VGND VGND VPWR VPWR tree_instances\[19\].u_tree.pipeline_frame_id\[0\]\[2\]
+ sky130_fd_sc_hd__dfrtp_1
XANTENNA_clkbuf_leaf_30_clk_A clknet_3_6__leaf_clk VGND VGND VPWR VPWR sky130_fd_sc_hd__diode_2
X_3807_ _1246_ VGND VGND VPWR VPWR _0348_ sky130_fd_sc_hd__clkbuf_1
XFILLER_0_51_82 VGND VGND VPWR VPWR sky130_fd_sc_hd__fill_2
X_4787_ clknet_leaf_42_clk _0475_ net10 VGND VGND VPWR VPWR tree_instances\[16\].u_tree.pipeline_frame_id\[0\]\[4\]
+ sky130_fd_sc_hd__dfrtp_1
XFILLER_0_27_181 VGND VGND VPWR VPWR sky130_fd_sc_hd__fill_1
XANTENNA__4170__S _0018_ VGND VGND VPWR VPWR sky130_fd_sc_hd__diode_2
XFILLER_0_70_471 VGND VGND VPWR VPWR sky130_fd_sc_hd__fill_2
X_3738_ _1203_ _1209_ VGND VGND VPWR VPWR _1211_ sky130_fd_sc_hd__and2_1
XFILLER_0_30_302 VGND VGND VPWR VPWR sky130_fd_sc_hd__fill_2
XFILLER_0_42_162 VGND VGND VPWR VPWR sky130_fd_sc_hd__decap_6
X_3669_ _1169_ VGND VGND VPWR VPWR _0287_ sky130_fd_sc_hd__clkbuf_1
XFILLER_0_30_335 VPWR VGND VPWR VGND sky130_ef_sc_hd__decap_12
XANTENNA_clkbuf_leaf_45_clk_A clknet_3_4__leaf_clk VGND VGND VPWR VPWR sky130_fd_sc_hd__diode_2
Xclkbuf_leaf_67_clk clknet_3_1__leaf_clk VGND VGND VPWR VPWR clknet_leaf_67_clk sky130_fd_sc_hd__clkbuf_4
XTAP_TAPCELL_ROW_87_1074 VGND VPWR sky130_fd_sc_hd__tapvpwrvgnd_1
XFILLER_0_53_416 VGND VGND VPWR VPWR sky130_fd_sc_hd__decap_8
XFILLER_0_53_438 VGND VGND VPWR VPWR sky130_fd_sc_hd__decap_8
XFILLER_0_53_449 VGND VGND VPWR VPWR sky130_fd_sc_hd__decap_6
XFILLER_0_80_235 VGND VGND VPWR VPWR sky130_fd_sc_hd__fill_2
Xclkbuf_leaf_58_clk clknet_3_4__leaf_clk VGND VGND VPWR VPWR clknet_leaf_58_clk sky130_fd_sc_hd__clkbuf_4
XFILLER_0_88_313 VGND VGND VPWR VPWR sky130_fd_sc_hd__decap_8
XTAP_TAPCELL_ROW_77_978 VGND VPWR sky130_fd_sc_hd__tapvpwrvgnd_1
XFILLER_0_72_15 VGND VGND VPWR VPWR sky130_fd_sc_hd__decap_6
XANTENNA__4743__RESET_B net9 VGND VGND VPWR VPWR sky130_fd_sc_hd__diode_2
XTAP_TAPCELL_ROW_60_812 VGND VPWR sky130_fd_sc_hd__tapvpwrvgnd_1
X_2971_ _0651_ net3 _0645_ VGND VGND VPWR VPWR _0652_ sky130_fd_sc_hd__mux2_1
XTAP_TAPCELL_ROW_32_525 VGND VPWR sky130_fd_sc_hd__tapvpwrvgnd_1
X_4710_ clknet_leaf_5_clk _0413_ net9 VGND VGND VPWR VPWR tree_instances\[13\].u_tree.frame_id_out\[0\]
+ sky130_fd_sc_hd__dfrtp_1
X_4641_ clknet_leaf_10_clk _0351_ tree_instances\[0\].u_tree.rst_n VGND VGND VPWR
+ VPWR tree_instances\[10\].u_tree.frame_id_out\[2\] sky130_fd_sc_hd__dfrtp_1
XFILLER_0_71_268 VGND VGND VPWR VPWR sky130_fd_sc_hd__fill_2
XFILLER_0_4_513 VPWR VGND VPWR VGND sky130_ef_sc_hd__decap_12
XFILLER_0_12_302 VGND VGND VPWR VPWR sky130_fd_sc_hd__decap_6
XFILLER_0_4_557 VPWR VGND VPWR VGND sky130_ef_sc_hd__decap_12
X_4572_ clknet_leaf_62_clk _0293_ net9 VGND VGND VPWR VPWR tree_instances\[7\].u_tree.ready_for_next
+ sky130_fd_sc_hd__dfstp_1
XFILLER_0_12_313 VGND VGND VPWR VPWR sky130_fd_sc_hd__fill_1
X_3523_ tree_instances\[5\].u_tree.pipeline_current_node\[0\]\[6\] VGND VGND VPWR
+ VPWR _1074_ sky130_fd_sc_hd__clkbuf_1
XFILLER_0_24_195 VGND VGND VPWR VPWR sky130_fd_sc_hd__fill_1
X_3454_ _1819_ _1029_ VGND VGND VPWR VPWR _1031_ sky130_fd_sc_hd__and2_1
X_2405_ _1760_ _1761_ VGND VGND VPWR VPWR _1762_ sky130_fd_sc_hd__or2_1
X_3385_ _0989_ VGND VGND VPWR VPWR _0183_ sky130_fd_sc_hd__clkbuf_1
X_2336_ tree_instances\[6\].u_tree.pipeline_current_node\[0\]\[1\] tree_instances\[6\].u_tree.pipeline_current_node\[0\]\[3\]
+ VGND VGND VPWR VPWR _1700_ sky130_fd_sc_hd__or2_1
X_2267_ _1641_ VGND VGND VPWR VPWR _1642_ sky130_fd_sc_hd__clkbuf_1
Xclkbuf_leaf_49_clk clknet_3_5__leaf_clk VGND VGND VPWR VPWR clknet_leaf_49_clk sky130_fd_sc_hd__clkbuf_4
XFILLER_0_46_60 VPWR VGND VPWR VGND sky130_ef_sc_hd__decap_12
X_4006_ _1364_ VGND VGND VPWR VPWR _0429_ sky130_fd_sc_hd__clkbuf_1
XFILLER_0_27_3 VPWR VGND VPWR VGND sky130_ef_sc_hd__decap_12
X_2198_ tree_instances\[12\].u_tree.tree_state\[3\] VGND VGND VPWR VPWR _1579_ sky130_fd_sc_hd__buf_2
XANTENNA__4484__RESET_B net9 VGND VGND VPWR VPWR sky130_fd_sc_hd__diode_2
XFILLER_0_1_51 VGND VGND VPWR VPWR sky130_fd_sc_hd__decap_4
XTAP_TAPCELL_ROW_48_691 VGND VPWR sky130_fd_sc_hd__tapvpwrvgnd_1
XANTENNA__4413__RESET_B net11 VGND VGND VPWR VPWR sky130_fd_sc_hd__diode_2
XFILLER_0_1_84 VGND VGND VPWR VPWR sky130_fd_sc_hd__fill_2
XFILLER_0_47_221 VGND VGND VPWR VPWR sky130_fd_sc_hd__decap_3
XFILLER_0_7_351 VGND VGND VPWR VPWR sky130_fd_sc_hd__fill_1
XFILLER_0_62_235 VGND VGND VPWR VPWR sky130_fd_sc_hd__fill_2
XFILLER_0_7_362 VPWR VGND VPWR VGND sky130_ef_sc_hd__decap_12
XFILLER_0_35_449 VGND VGND VPWR VPWR sky130_fd_sc_hd__fill_2
X_4839_ clknet_leaf_49_clk _0521_ net10 VGND VGND VPWR VPWR tree_instances\[18\].u_tree.frame_id_out\[3\]
+ sky130_fd_sc_hd__dfrtp_1
XFILLER_0_30_110 VGND VGND VPWR VPWR sky130_fd_sc_hd__fill_2
XFILLER_0_30_165 VGND VGND VPWR VPWR sky130_fd_sc_hd__decap_3
XFILLER_0_30_176 VGND VGND VPWR VPWR sky130_fd_sc_hd__fill_1
XTAP_TAPCELL_ROW_89_1103 VGND VPWR sky130_fd_sc_hd__tapvpwrvgnd_1
XPHY_EDGE_ROW_42_Left_139 VGND VGND VPWR VPWR sky130_fd_sc_hd__decap_3
XTAP_TAPCELL_ROW_74_948 VGND VPWR sky130_fd_sc_hd__tapvpwrvgnd_1
XFILLER_0_58_508 VGND VGND VPWR VPWR sky130_fd_sc_hd__fill_2
XFILLER_0_85_305 VPWR VGND VPWR VGND sky130_ef_sc_hd__decap_12
XFILLER_0_66_530 VGND VGND VPWR VPWR sky130_fd_sc_hd__fill_2
XPHY_EDGE_ROW_51_Left_148 VGND VGND VPWR VPWR sky130_fd_sc_hd__decap_3
XFILLER_0_38_276 VGND VGND VPWR VPWR sky130_fd_sc_hd__decap_4
XFILLER_0_53_257 VGND VGND VPWR VPWR sky130_fd_sc_hd__decap_3
XFILLER_0_34_471 VGND VGND VPWR VPWR sky130_fd_sc_hd__decap_4
XFILLER_0_61_290 VPWR VGND VPWR VGND sky130_ef_sc_hd__decap_12
XFILLER_0_1_505 VPWR VGND VPWR VGND sky130_ef_sc_hd__decap_12
XFILLER_0_6_29 VPWR VGND VPWR VGND sky130_ef_sc_hd__decap_12
XPHY_EDGE_ROW_60_Left_157 VGND VGND VPWR VPWR sky130_fd_sc_hd__decap_3
X_3170_ _0835_ _0837_ _0841_ VGND VGND VPWR VPWR _0842_ sky130_fd_sc_hd__and3_1
XFILLER_0_83_69 VGND VGND VPWR VPWR sky130_fd_sc_hd__fill_1
XFILLER_0_83_47 VGND VGND VPWR VPWR sky130_fd_sc_hd__decap_3
XFILLER_0_16_85 VPWR VGND VPWR VGND sky130_ef_sc_hd__decap_12
XFILLER_0_49_519 VGND VGND VPWR VPWR sky130_fd_sc_hd__decap_8
XFILLER_0_57_530 VPWR VGND VPWR VGND sky130_ef_sc_hd__decap_12
XTAP_TAPCELL_ROW_45_661 VGND VPWR sky130_fd_sc_hd__tapvpwrvgnd_1
XFILLER_0_8_115 VGND VGND VPWR VPWR sky130_fd_sc_hd__fill_2
XTAP_TAPCELL_ROW_17_374 VGND VPWR sky130_fd_sc_hd__tapvpwrvgnd_1
X_2954_ tree_instances\[19\].u_tree.tree_state\[0\] VGND VGND VPWR VPWR _0639_ sky130_fd_sc_hd__inv_2
XFILLER_0_17_438 VGND VGND VPWR VPWR sky130_fd_sc_hd__decap_8
XFILLER_0_72_533 VPWR VGND VPWR VGND sky130_ef_sc_hd__decap_12
XFILLER_0_17_449 VPWR VGND VPWR VGND sky130_ef_sc_hd__decap_12
X_2885_ _0581_ VGND VGND VPWR VPWR _0592_ sky130_fd_sc_hd__clkbuf_1
XFILLER_0_32_95 VGND VGND VPWR VPWR sky130_fd_sc_hd__fill_2
XPHY_EDGE_ROW_6_Right_6 VGND VGND VPWR VPWR sky130_fd_sc_hd__decap_3
XFILLER_0_4_321 VPWR VGND VPWR VGND sky130_ef_sc_hd__decap_12
X_4624_ clknet_leaf_8_clk _0334_ net12 VGND VGND VPWR VPWR tree_instances\[9\].u_tree.pipeline_valid\[0\]
+ sky130_fd_sc_hd__dfrtp_1
XFILLER_0_4_365 VGND VGND VPWR VPWR sky130_fd_sc_hd__decap_8
X_4555_ clknet_leaf_66_clk _0276_ tree_instances\[0\].u_tree.rst_n VGND VGND VPWR
+ VPWR tree_instances\[7\].u_tree.pipeline_current_node\[0\]\[2\] sky130_fd_sc_hd__dfrtp_1
XANTENNA__4496__SET_B tree_instances\[0\].u_tree.rst_n VGND VGND VPWR VPWR sky130_fd_sc_hd__diode_2
X_3506_ _1060_ VGND VGND VPWR VPWR _1061_ sky130_fd_sc_hd__clkbuf_1
X_4486_ clknet_leaf_60_clk _0226_ tree_instances\[0\].u_tree.rst_n VGND VGND VPWR
+ VPWR tree_instances\[4\].u_tree.frame_id_out\[2\] sky130_fd_sc_hd__dfrtp_1
X_3437_ _1872_ _1016_ _0630_ tree_instances\[3\].u_tree.ready_for_next VGND VGND VPWR
+ VPWR _0208_ sky130_fd_sc_hd__a22o_1
X_3368_ _0980_ _0959_ VGND VGND VPWR VPWR _0981_ sky130_fd_sc_hd__and2_1
X_2319_ _1575_ tree_instances\[7\].u_tree.pipeline_valid\[0\] VGND VGND VPWR VPWR
+ _1686_ sky130_fd_sc_hd__or2_1
XANTENNA__4665__RESET_B tree_instances\[0\].u_tree.rst_n VGND VGND VPWR VPWR sky130_fd_sc_hd__diode_2
XFILLER_0_57_81 VGND VGND VPWR VPWR sky130_fd_sc_hd__fill_1
X_3299_ _0938_ VGND VGND VPWR VPWR _0148_ sky130_fd_sc_hd__clkbuf_1
XFILLER_0_79_121 VGND VGND VPWR VPWR sky130_fd_sc_hd__decap_6
XTAP_TAPCELL_ROW_84_1044 VGND VPWR sky130_fd_sc_hd__tapvpwrvgnd_1
XTAP_TAPCELL_ROW_71_918 VGND VPWR sky130_fd_sc_hd__tapvpwrvgnd_1
XFILLER_0_35_202 VPWR VGND VPWR VGND sky130_ef_sc_hd__decap_12
XFILLER_0_75_393 VGND VGND VPWR VPWR sky130_fd_sc_hd__decap_4
XFILLER_0_16_493 VPWR VGND VPWR VGND sky130_ef_sc_hd__decap_12
XFILLER_0_50_227 VGND VGND VPWR VPWR sky130_fd_sc_hd__fill_2
XTAP_TAPCELL_ROW_95_1162 VGND VPWR sky130_fd_sc_hd__tapvpwrvgnd_1
Xoutput8 net8 VGND VGND VPWR VPWR ready_for_next sky130_fd_sc_hd__buf_8
XFILLER_0_31_474 VPWR VGND VPWR VGND sky130_ef_sc_hd__decap_12
XANTENNA__4335__RESET_B net11 VGND VGND VPWR VPWR sky130_fd_sc_hd__diode_2
XTAP_TAPCELL_ROW_59_797 VGND VPWR sky130_fd_sc_hd__tapvpwrvgnd_1
XFILLER_0_58_316 VPWR VGND VPWR VGND sky130_ef_sc_hd__decap_12
XFILLER_0_85_113 VPWR VGND VPWR VGND sky130_ef_sc_hd__decap_12
XTAP_TAPCELL_ROW_42_631 VGND VPWR sky130_fd_sc_hd__tapvpwrvgnd_1
XTAP_TAPCELL_ROW_14_344 VGND VPWR sky130_fd_sc_hd__tapvpwrvgnd_1
XFILLER_0_81_341 VPWR VGND VPWR VGND sky130_ef_sc_hd__decap_12
XPHY_EDGE_ROW_59_Right_59 VGND VGND VPWR VPWR sky130_fd_sc_hd__decap_3
XFILLER_0_5_118 VGND VGND VPWR VPWR sky130_fd_sc_hd__fill_2
XFILLER_0_54_533 VGND VGND VPWR VPWR sky130_fd_sc_hd__fill_1
X_2670_ _1991_ VGND VGND VPWR VPWR _1992_ sky130_fd_sc_hd__clkbuf_1
XFILLER_0_14_419 VGND VGND VPWR VPWR sky130_fd_sc_hd__fill_1
XFILLER_0_1_368 VGND VGND VPWR VPWR sky130_fd_sc_hd__decap_6
X_4340_ clknet_leaf_48_clk _0084_ net10 VGND VGND VPWR VPWR tree_instances\[18\].u_tree.tree_state\[3\]
+ sky130_fd_sc_hd__dfrtp_1
X_4271_ tree_instances\[19\].u_tree.frame_id_out\[1\] tree_instances\[19\].u_tree.pipeline_frame_id\[0\]\[1\]
+ _1970_ VGND VGND VPWR VPWR _1518_ sky130_fd_sc_hd__mux2_1
XFILLER_0_94_35 VGND VGND VPWR VPWR sky130_fd_sc_hd__fill_1
X_3222_ complete_votes\[2\] VGND VGND VPWR VPWR _0892_ sky130_fd_sc_hd__inv_2
XFILLER_0_94_46 VPWR VGND VPWR VGND sky130_ef_sc_hd__decap_12
XPHY_EDGE_ROW_68_Right_68 VGND VGND VPWR VPWR sky130_fd_sc_hd__decap_3
X_3153_ _0655_ _0818_ _0819_ _0824_ VGND VGND VPWR VPWR _0825_ sky130_fd_sc_hd__o211a_1
XFILLER_0_27_51 VGND VGND VPWR VPWR sky130_fd_sc_hd__decap_4
X_3084_ _0686_ tree_instances\[19\].u_tree.frame_id_out\[1\] _0748_ _0655_ _0755_
+ VGND VGND VPWR VPWR _0756_ sky130_fd_sc_hd__a221o_1
XFILLER_0_43_50 VGND VGND VPWR VPWR sky130_fd_sc_hd__fill_2
XFILLER_0_49_349 VGND VGND VPWR VPWR sky130_fd_sc_hd__fill_2
XFILLER_0_91_105 VGND VGND VPWR VPWR sky130_fd_sc_hd__decap_6
XPHY_EDGE_ROW_77_Right_77 VGND VGND VPWR VPWR sky130_fd_sc_hd__decap_3
X_3986_ _1353_ VGND VGND VPWR VPWR _1354_ sky130_fd_sc_hd__buf_1
XFILLER_0_9_446 VGND VGND VPWR VPWR sky130_fd_sc_hd__fill_2
XFILLER_0_17_202 VGND VGND VPWR VPWR sky130_fd_sc_hd__fill_2
XANTENNA__3600__A1 _1124_ VGND VGND VPWR VPWR sky130_fd_sc_hd__diode_2
XFILLER_0_72_330 VGND VGND VPWR VPWR sky130_fd_sc_hd__decap_6
XFILLER_0_57_393 VPWR VGND VPWR VGND sky130_ef_sc_hd__decap_12
X_2937_ _1627_ tree_instances\[17\].u_tree.tree_state\[2\] VGND VGND VPWR VPWR _0628_
+ sky130_fd_sc_hd__and2b_1
XFILLER_0_45_555 VGND VGND VPWR VPWR sky130_fd_sc_hd__decap_4
X_2868_ _2163_ VGND VGND VPWR VPWR _0575_ sky130_fd_sc_hd__clkbuf_1
X_4607_ clknet_leaf_68_clk _0322_ net9 VGND VGND VPWR VPWR tree_instances\[9\].u_tree.pipeline_current_node\[0\]\[8\]
+ sky130_fd_sc_hd__dfrtp_1
X_2799_ _2096_ VGND VGND VPWR VPWR _2104_ sky130_fd_sc_hd__clkbuf_1
XFILLER_0_4_173 VGND VGND VPWR VPWR sky130_fd_sc_hd__fill_2
X_4538_ clknet_leaf_23_clk _0268_ net11 VGND VGND VPWR VPWR tree_instances\[6\].u_tree.frame_id_out\[1\]
+ sky130_fd_sc_hd__dfrtp_1
XFILLER_0_13_496 VGND VGND VPWR VPWR sky130_fd_sc_hd__decap_8
XFILLER_0_13_463 VPWR VGND VPWR VGND sky130_ef_sc_hd__decap_12
XANTENNA__4846__RESET_B net10 VGND VGND VPWR VPWR sky130_fd_sc_hd__diode_2
X_4469_ clknet_leaf_1_clk _0209_ net9 VGND VGND VPWR VPWR tree_instances\[13\].u_tree.pipeline_valid\[0\]
+ sky130_fd_sc_hd__dfrtp_1
XPHY_EDGE_ROW_86_Right_86 VGND VGND VPWR VPWR sky130_fd_sc_hd__decap_3
XANTENNA__4092__A1 _0664_ VGND VGND VPWR VPWR sky130_fd_sc_hd__diode_2
XTAP_TAPCELL_ROW_56_767 VGND VPWR sky130_fd_sc_hd__tapvpwrvgnd_1
XPHY_EDGE_ROW_95_Right_95 VGND VGND VPWR VPWR sky130_fd_sc_hd__decap_3
XFILLER_0_48_371 VGND VGND VPWR VPWR sky130_fd_sc_hd__fill_2
XFILLER_0_36_533 VPWR VGND VPWR VGND sky130_ef_sc_hd__decap_12
XFILLER_0_63_352 VGND VGND VPWR VPWR sky130_fd_sc_hd__fill_2
XFILLER_0_63_341 VGND VGND VPWR VPWR sky130_fd_sc_hd__decap_4
XTAP_TAPCELL_ROW_11_314 VGND VPWR sky130_fd_sc_hd__tapvpwrvgnd_1
XFILLER_0_63_385 VGND VGND VPWR VPWR sky130_fd_sc_hd__decap_6
XFILLER_0_23_249 VGND VGND VPWR VPWR sky130_fd_sc_hd__decap_6
XANTENNA__4587__RESET_B net12 VGND VGND VPWR VPWR sky130_fd_sc_hd__diode_2
XANTENNA__4516__RESET_B tree_instances\[0\].u_tree.rst_n VGND VGND VPWR VPWR sky130_fd_sc_hd__diode_2
XANTENNA__3658__A1 _1162_ VGND VGND VPWR VPWR sky130_fd_sc_hd__diode_2
XFILLER_0_64_27 VGND VGND VPWR VPWR sky130_fd_sc_hd__fill_1
XTAP_TAPCELL_ROW_19_403 VGND VPWR sky130_fd_sc_hd__tapvpwrvgnd_1
XTAP_TAPCELL_ROW_27_480 VGND VPWR sky130_fd_sc_hd__tapvpwrvgnd_1
X_3840_ _2028_ _1254_ VGND VGND VPWR VPWR _1264_ sky130_fd_sc_hd__and2_1
XFILLER_0_73_138 VPWR VGND VPWR VGND sky130_ef_sc_hd__decap_12
XFILLER_0_39_382 VGND VGND VPWR VPWR sky130_fd_sc_hd__decap_8
X_3771_ _1227_ VGND VGND VPWR VPWR _0331_ sky130_fd_sc_hd__clkbuf_1
X_2722_ _2037_ VGND VGND VPWR VPWR _2038_ sky130_fd_sc_hd__clkbuf_1
XFILLER_0_54_363 VGND VGND VPWR VPWR sky130_fd_sc_hd__fill_1
X_2653_ tree_instances\[19\].u_tree.pipeline_current_node\[0\]\[3\] VGND VGND VPWR
+ VPWR _1975_ sky130_fd_sc_hd__clkbuf_1
X_2584_ _1915_ _1916_ VGND VGND VPWR VPWR _1917_ sky130_fd_sc_hd__nor2_1
X_4323_ net1 net8 state\[0\] VGND VGND VPWR VPWR _1544_ sky130_fd_sc_hd__a21o_1
XFILLER_0_10_433 VGND VGND VPWR VPWR sky130_fd_sc_hd__fill_2
X_4254_ _1509_ VGND VGND VPWR VPWR _0532_ sky130_fd_sc_hd__clkbuf_1
X_3205_ _0733_ tree_instances\[5\].u_tree.frame_id_out\[1\] VGND VGND VPWR VPWR _0877_
+ sky130_fd_sc_hd__and2b_1
X_4185_ _1473_ VGND VGND VPWR VPWR _0499_ sky130_fd_sc_hd__clkbuf_1
X_3136_ _0795_ _0799_ _0807_ VGND VGND VPWR VPWR _0808_ sky130_fd_sc_hd__a21oi_1
X_3067_ _0732_ _0735_ _0738_ VGND VGND VPWR VPWR _0739_ sky130_fd_sc_hd__and3b_1
XFILLER_0_89_271 VGND VGND VPWR VPWR sky130_fd_sc_hd__decap_8
XFILLER_0_54_82 VGND VGND VPWR VPWR sky130_fd_sc_hd__fill_2
XTAP_TAPCELL_ROW_81_1014 VGND VPWR sky130_fd_sc_hd__tapvpwrvgnd_1
XTAP_TAPCELL_ROW_53_737 VGND VPWR sky130_fd_sc_hd__tapvpwrvgnd_1
XFILLER_0_92_425 VGND VGND VPWR VPWR sky130_fd_sc_hd__decap_8
XFILLER_0_77_477 VPWR VGND VPWR VGND sky130_ef_sc_hd__decap_12
XFILLER_0_92_458 VGND VGND VPWR VPWR sky130_fd_sc_hd__fill_2
XFILLER_0_64_149 VGND VGND VPWR VPWR sky130_fd_sc_hd__decap_8
XFILLER_0_18_533 VPWR VGND VPWR VGND sky130_ef_sc_hd__decap_12
X_3969_ _1345_ VGND VGND VPWR VPWR _0411_ sky130_fd_sc_hd__clkbuf_1
XFILLER_0_45_341 VPWR VGND VPWR VGND sky130_ef_sc_hd__decap_12
XFILLER_0_45_363 VPWR VGND VPWR VGND sky130_ef_sc_hd__decap_12
XFILLER_0_72_193 VGND VGND VPWR VPWR sky130_fd_sc_hd__decap_3
XFILLER_0_60_333 VPWR VGND VPWR VGND sky130_ef_sc_hd__decap_12
XFILLER_0_60_399 VGND VGND VPWR VPWR sky130_fd_sc_hd__fill_1
XFILLER_0_60_377 VGND VGND VPWR VPWR sky130_fd_sc_hd__decap_3
XTAP_TAPCELL_ROW_92_1132 VGND VPWR sky130_fd_sc_hd__tapvpwrvgnd_1
XANTENNA__4680__RESET_B net11 VGND VGND VPWR VPWR sky130_fd_sc_hd__diode_2
XFILLER_0_13_293 VPWR VGND VPWR VGND sky130_ef_sc_hd__decap_12
XANTENNA__2392__A _1575_ VGND VGND VPWR VPWR sky130_fd_sc_hd__diode_2
XFILLER_0_83_447 VGND VGND VPWR VPWR sky130_fd_sc_hd__fill_1
XTAP_TAPCELL_ROW_24_450 VGND VPWR sky130_fd_sc_hd__tapvpwrvgnd_1
XFILLER_0_50_29 VPWR VGND VPWR VGND sky130_ef_sc_hd__decap_12
XANTENNA__4768__RESET_B net10 VGND VGND VPWR VPWR sky130_fd_sc_hd__diode_2
XFILLER_0_24_569 VGND VGND VPWR VPWR sky130_fd_sc_hd__decap_4
XFILLER_0_51_333 VGND VGND VPWR VPWR sky130_fd_sc_hd__decap_3
XANTENNA__4350__RESET_B net11 VGND VGND VPWR VPWR sky130_fd_sc_hd__diode_2
XANTENNA__4337__SET_B net10 VGND VGND VPWR VPWR sky130_fd_sc_hd__diode_2
XANTENNA__4056__A1 tree_instances\[0\].u_tree.frame_id_in\[4\] VGND VGND VPWR VPWR
+ sky130_fd_sc_hd__diode_2
XFILLER_0_91_69 VPWR VGND VPWR VGND sky130_ef_sc_hd__decap_12
XFILLER_0_24_85 VGND VGND VPWR VPWR sky130_fd_sc_hd__fill_2
XTAP_TAPCELL_ROW_50_707 VGND VPWR sky130_fd_sc_hd__tapvpwrvgnd_1
X_4872_ clknet_leaf_42_clk _0016_ net10 VGND VGND VPWR VPWR tree_instances\[16\].u_tree.tree_state\[2\]
+ sky130_fd_sc_hd__dfrtp_1
X_3823_ tree_instances\[11\].u_tree.tree_state\[2\] tree_instances\[11\].u_tree.tree_state\[1\]
+ _0608_ VGND VGND VPWR VPWR _1254_ sky130_fd_sc_hd__or3_1
XFILLER_0_46_149 VPWR VGND VPWR VGND sky130_ef_sc_hd__decap_12
XFILLER_0_15_503 VGND VGND VPWR VPWR sky130_fd_sc_hd__fill_1
XFILLER_0_27_341 VPWR VGND VPWR VGND sky130_ef_sc_hd__decap_12
X_3754_ tree_instances\[9\].u_tree.pipeline_frame_id\[0\]\[0\] _1162_ _0042_ VGND
+ VGND VPWR VPWR _1219_ sky130_fd_sc_hd__mux2_1
XFILLER_0_42_300 VGND VGND VPWR VPWR sky130_fd_sc_hd__fill_2
X_3685_ _1178_ VGND VGND VPWR VPWR _1179_ sky130_fd_sc_hd__dlymetal6s2s_1
X_2705_ tree_instances\[3\].u_tree.prediction_valid _1872_ VGND VGND VPWR VPWR _2024_
+ sky130_fd_sc_hd__and2b_1
XANTENNA__4438__RESET_B net12 VGND VGND VPWR VPWR sky130_fd_sc_hd__diode_2
X_2636_ tree_instances\[18\].u_tree.pipeline_current_node\[0\]\[4\] VGND VGND VPWR
+ VPWR _1962_ sky130_fd_sc_hd__clkbuf_1
XFILLER_0_42_399 VGND VGND VPWR VPWR sky130_fd_sc_hd__fill_1
X_2567_ tree_instances\[20\].u_tree.tree_state\[2\] _1898_ _1904_ tree_instances\[20\].u_tree.tree_state\[1\]
+ VGND VGND VPWR VPWR _0066_ sky130_fd_sc_hd__a31o_1
XFILLER_0_57_3 VPWR VGND VPWR VGND sky130_ef_sc_hd__decap_12
X_4306_ tree_instances\[20\].u_tree.pipeline_frame_id\[0\]\[2\] _0674_ _0026_ VGND
+ VGND VPWR VPWR _1536_ sky130_fd_sc_hd__mux2_1
XFILLER_0_10_296 VGND VGND VPWR VPWR sky130_fd_sc_hd__fill_1
X_2498_ _1843_ VGND VGND VPWR VPWR _1844_ sky130_fd_sc_hd__clkbuf_1
X_4237_ tree_instances\[19\].u_tree.tree_state\[0\] _1969_ VGND VGND VPWR VPWR _1500_
+ sky130_fd_sc_hd__nand2_1
X_4168_ tree_instances\[17\].u_tree.pipeline_current_node\[0\]\[8\] _1443_ VGND VGND
+ VPWR VPWR _1465_ sky130_fd_sc_hd__and2_1
XANTENNA_clkbuf_leaf_4_clk_A clknet_3_0__leaf_clk VGND VGND VPWR VPWR sky130_fd_sc_hd__diode_2
XTAP_TAPCELL_ROW_66_873 VGND VPWR sky130_fd_sc_hd__tapvpwrvgnd_1
X_4099_ _1412_ VGND VGND VPWR VPWR _0474_ sky130_fd_sc_hd__clkbuf_1
X_3119_ _0655_ _0783_ _2025_ _0789_ _0790_ VGND VGND VPWR VPWR _0791_ sky130_fd_sc_hd__a2111o_1
XTAP_TAPCELL_ROW_38_586 VGND VPWR sky130_fd_sc_hd__tapvpwrvgnd_1
XFILLER_0_92_200 VGND VGND VPWR VPWR sky130_fd_sc_hd__decap_4
XFILLER_0_65_436 VPWR VGND VPWR VGND sky130_ef_sc_hd__decap_12
XTAP_TAPCELL_ROW_21_420 VGND VPWR sky130_fd_sc_hd__tapvpwrvgnd_1
XFILLER_0_92_288 VGND VGND VPWR VPWR sky130_fd_sc_hd__decap_3
XFILLER_0_80_428 VPWR VGND VPWR VGND sky130_ef_sc_hd__decap_12
XANTENNA__4861__RESET_B net13 VGND VGND VPWR VPWR sky130_fd_sc_hd__diode_2
XFILLER_0_60_141 VGND VGND VPWR VPWR sky130_fd_sc_hd__fill_2
XFILLER_0_33_333 VGND VGND VPWR VPWR sky130_fd_sc_hd__decap_3
XFILLER_0_60_163 VPWR VGND VPWR VGND sky130_ef_sc_hd__decap_12
XFILLER_0_21_517 VGND VGND VPWR VPWR sky130_fd_sc_hd__decap_4
XFILLER_0_88_539 VGND VGND VPWR VPWR sky130_fd_sc_hd__fill_1
XFILLER_0_68_241 VGND VGND VPWR VPWR sky130_fd_sc_hd__decap_8
XFILLER_0_96_561 VGND VGND VPWR VPWR sky130_fd_sc_hd__fill_1
XFILLER_0_83_222 VGND VGND VPWR VPWR sky130_fd_sc_hd__fill_2
XFILLER_0_83_266 VGND VGND VPWR VPWR sky130_fd_sc_hd__decap_8
XFILLER_0_83_288 VGND VGND VPWR VPWR sky130_fd_sc_hd__fill_1
XFILLER_0_24_333 VGND VGND VPWR VPWR sky130_fd_sc_hd__decap_6
XANTENNA__4531__RESET_B net11 VGND VGND VPWR VPWR sky130_fd_sc_hd__diode_2
XFILLER_0_10_65 VPWR VGND VPWR VGND sky130_ef_sc_hd__decap_12
X_3470_ tree_instances\[4\].u_tree.pipeline_frame_id\[0\]\[0\] _0665_ _0032_ VGND
+ VGND VPWR VPWR _1039_ sky130_fd_sc_hd__mux2_1
X_2421_ tree_instances\[16\].u_tree.pipeline_current_node\[0\]\[3\] VGND VGND VPWR
+ VPWR _1775_ sky130_fd_sc_hd__clkbuf_1
X_2352_ tree_instances\[13\].u_tree.pipeline_current_node\[0\]\[8\] tree_instances\[13\].u_tree.pipeline_current_node\[0\]\[7\]
+ VGND VGND VPWR VPWR _1715_ sky130_fd_sc_hd__or2_1
X_2283_ _1651_ _1653_ VGND VGND VPWR VPWR _1654_ sky130_fd_sc_hd__nor2_1
XANTENNA__2297__A _1666_ VGND VGND VPWR VPWR sky130_fd_sc_hd__diode_2
X_4022_ _1372_ VGND VGND VPWR VPWR _0437_ sky130_fd_sc_hd__clkbuf_1
XFILLER_0_87_561 VPWR VGND VPWR VGND sky130_ef_sc_hd__decap_12
XFILLER_0_87_550 VGND VGND VPWR VPWR sky130_fd_sc_hd__decap_8
XTAP_TAPCELL_ROW_63_843 VGND VPWR sky130_fd_sc_hd__tapvpwrvgnd_1
XFILLER_0_59_252 VGND VGND VPWR VPWR sky130_fd_sc_hd__fill_2
XTAP_TAPCELL_ROW_35_556 VGND VPWR sky130_fd_sc_hd__tapvpwrvgnd_1
XFILLER_0_74_222 VGND VGND VPWR VPWR sky130_fd_sc_hd__fill_2
X_4855_ clknet_leaf_43_clk _0536_ net10 VGND VGND VPWR VPWR tree_instances\[19\].u_tree.pipeline_frame_id\[0\]\[1\]
+ sky130_fd_sc_hd__dfrtp_1
XFILLER_0_19_149 VGND VGND VPWR VPWR sky130_fd_sc_hd__decap_8
XFILLER_0_51_61 VGND VGND VPWR VPWR sky130_fd_sc_hd__decap_8
X_4786_ clknet_leaf_43_clk _0474_ net13 VGND VGND VPWR VPWR tree_instances\[16\].u_tree.pipeline_frame_id\[0\]\[3\]
+ sky130_fd_sc_hd__dfrtp_1
XFILLER_0_34_108 VPWR VGND VPWR VGND sky130_ef_sc_hd__decap_12
XANTENNA__4619__RESET_B tree_instances\[0\].u_tree.rst_n VGND VGND VPWR VPWR sky130_fd_sc_hd__diode_2
X_3806_ tree_instances\[10\].u_tree.pipeline_frame_id\[0\]\[4\] _1168_ _0004_ VGND
+ VGND VPWR VPWR _1246_ sky130_fd_sc_hd__mux2_1
X_3737_ _1210_ VGND VGND VPWR VPWR _0314_ sky130_fd_sc_hd__clkbuf_1
XFILLER_0_42_141 VGND VGND VPWR VPWR sky130_fd_sc_hd__decap_6
X_3668_ tree_instances\[7\].u_tree.pipeline_frame_id\[0\]\[4\] _1168_ _0038_ VGND
+ VGND VPWR VPWR _1169_ sky130_fd_sc_hd__mux2_1
XFILLER_0_30_347 VGND VGND VPWR VPWR sky130_fd_sc_hd__decap_4
XFILLER_0_42_174 VGND VGND VPWR VPWR sky130_fd_sc_hd__decap_4
X_2619_ tree_instances\[19\].u_tree.pipeline_current_node\[0\]\[8\] tree_instances\[19\].u_tree.pipeline_current_node\[0\]\[7\]
+ VGND VGND VPWR VPWR _1947_ sky130_fd_sc_hd__nor2_1
X_3599_ tree_instances\[0\].u_tree.frame_id_in\[1\] VGND VGND VPWR VPWR _1124_ sky130_fd_sc_hd__clkbuf_4
XFILLER_0_11_561 VPWR VGND VPWR VGND sky130_ef_sc_hd__decap_12
XFILLER_0_30_369 VGND VGND VPWR VPWR sky130_fd_sc_hd__fill_1
XFILLER_0_2_293 VGND VGND VPWR VPWR sky130_fd_sc_hd__fill_2
XTAP_TAPCELL_ROW_87_1075 VGND VPWR sky130_fd_sc_hd__tapvpwrvgnd_1
XFILLER_0_25_108 VGND VGND VPWR VPWR sky130_fd_sc_hd__fill_2
XFILLER_0_46_491 VGND VGND VPWR VPWR sky130_fd_sc_hd__decap_4
XFILLER_0_21_347 VGND VGND VPWR VPWR sky130_fd_sc_hd__fill_2
XANTENNA__4671__SET_B net12 VGND VGND VPWR VPWR sky130_fd_sc_hd__diode_2
XANTENNA__3006__A _0678_ VGND VGND VPWR VPWR sky130_fd_sc_hd__diode_2
XANTENNA__4259__A1 _0664_ VGND VGND VPWR VPWR sky130_fd_sc_hd__diode_2
XTAP_TAPCELL_ROW_6_270 VGND VPWR sky130_fd_sc_hd__tapvpwrvgnd_1
XTAP_TAPCELL_ROW_77_979 VGND VPWR sky130_fd_sc_hd__tapvpwrvgnd_1
XFILLER_0_72_27 VGND VGND VPWR VPWR sky130_fd_sc_hd__fill_1
XFILLER_0_84_520 VPWR VGND VPWR VGND sky130_ef_sc_hd__decap_12
XTAP_TAPCELL_ROW_60_813 VGND VPWR sky130_fd_sc_hd__tapvpwrvgnd_1
XFILLER_0_29_447 VGND VGND VPWR VPWR sky130_fd_sc_hd__fill_1
X_2970_ _0650_ VGND VGND VPWR VPWR _0651_ sky130_fd_sc_hd__clkbuf_4
XTAP_TAPCELL_ROW_32_526 VGND VPWR sky130_fd_sc_hd__tapvpwrvgnd_1
XANTENNA__4783__RESET_B net13 VGND VGND VPWR VPWR sky130_fd_sc_hd__diode_2
XFILLER_0_71_225 VGND VGND VPWR VPWR sky130_fd_sc_hd__fill_2
XFILLER_0_71_203 VGND VGND VPWR VPWR sky130_fd_sc_hd__decap_8
XFILLER_0_21_20 VGND VGND VPWR VPWR sky130_fd_sc_hd__fill_1
XANTENNA__4712__RESET_B net9 VGND VGND VPWR VPWR sky130_fd_sc_hd__diode_2
X_4640_ clknet_leaf_4_clk _0350_ tree_instances\[0\].u_tree.rst_n VGND VGND VPWR VPWR
+ tree_instances\[10\].u_tree.frame_id_out\[1\] sky130_fd_sc_hd__dfrtp_1
XFILLER_0_4_525 VGND VGND VPWR VPWR sky130_fd_sc_hd__decap_6
XFILLER_0_24_141 VGND VGND VPWR VPWR sky130_fd_sc_hd__decap_6
X_4571_ clknet_leaf_5_clk _0292_ net9 VGND VGND VPWR VPWR tree_instances\[7\].u_tree.frame_id_out\[4\]
+ sky130_fd_sc_hd__dfrtp_1
XFILLER_0_4_569 VGND VGND VPWR VPWR sky130_fd_sc_hd__decap_4
XFILLER_0_24_185 VGND VGND VPWR VPWR sky130_fd_sc_hd__fill_1
X_3522_ _1073_ VGND VGND VPWR VPWR _0236_ sky130_fd_sc_hd__clkbuf_1
X_3453_ _1030_ VGND VGND VPWR VPWR _0210_ sky130_fd_sc_hd__clkbuf_1
X_2404_ tree_instances\[5\].u_tree.pipeline_current_node\[0\]\[0\] tree_instances\[5\].u_tree.pipeline_current_node\[0\]\[3\]
+ VGND VGND VPWR VPWR _1761_ sky130_fd_sc_hd__or2_1
X_3384_ tree_instances\[2\].u_tree.frame_id_out\[1\] tree_instances\[2\].u_tree.pipeline_frame_id\[0\]\[1\]
+ _1891_ VGND VGND VPWR VPWR _0989_ sky130_fd_sc_hd__mux2_1
X_2335_ _1699_ VGND VGND VPWR VPWR _0013_ sky130_fd_sc_hd__clkbuf_1
X_2266_ tree_instances\[0\].u_tree.pipeline_current_node\[0\]\[4\] VGND VGND VPWR
+ VPWR _1641_ sky130_fd_sc_hd__clkbuf_1
X_2197_ _1574_ tree_instances\[12\].u_tree.pipeline_valid\[0\] VGND VGND VPWR VPWR
+ _1578_ sky130_fd_sc_hd__or2_1
X_4005_ tree_instances\[14\].u_tree.pipeline_frame_id\[0\]\[0\] _1162_ _0012_ VGND
+ VGND VPWR VPWR _1364_ sky130_fd_sc_hd__mux2_1
XFILLER_0_46_72 VPWR VGND VPWR VGND sky130_ef_sc_hd__decap_12
XFILLER_0_67_509 VGND VGND VPWR VPWR sky130_fd_sc_hd__fill_1
XTAP_TAPCELL_ROW_48_692 VGND VPWR sky130_fd_sc_hd__tapvpwrvgnd_1
XFILLER_0_47_233 VGND VGND VPWR VPWR sky130_fd_sc_hd__decap_3
XFILLER_0_7_341 VGND VGND VPWR VPWR sky130_fd_sc_hd__fill_1
XANTENNA__4453__RESET_B tree_instances\[0\].u_tree.rst_n VGND VGND VPWR VPWR sky130_fd_sc_hd__diode_2
XFILLER_0_35_417 VPWR VGND VPWR VGND sky130_ef_sc_hd__decap_12
X_4838_ clknet_leaf_46_clk _0520_ net13 VGND VGND VPWR VPWR tree_instances\[18\].u_tree.frame_id_out\[2\]
+ sky130_fd_sc_hd__dfrtp_1
XFILLER_0_7_374 VGND VGND VPWR VPWR sky130_fd_sc_hd__decap_6
X_4769_ clknet_leaf_42_clk _0054_ net10 VGND VGND VPWR VPWR tree_instances\[15\].u_tree.tree_state\[0\]
+ sky130_fd_sc_hd__dfstp_1
XFILLER_0_15_185 VPWR VGND VPWR VGND sky130_ef_sc_hd__decap_12
XANTENNA__3161__A1 _0662_ VGND VGND VPWR VPWR sky130_fd_sc_hd__diode_2
XTAP_TAPCELL_ROW_3_240 VGND VPWR sky130_fd_sc_hd__tapvpwrvgnd_1
XTAP_TAPCELL_ROW_74_949 VGND VPWR sky130_fd_sc_hd__tapvpwrvgnd_1
XFILLER_0_85_317 VGND VGND VPWR VPWR sky130_fd_sc_hd__decap_8
XFILLER_0_38_211 VGND VGND VPWR VPWR sky130_fd_sc_hd__fill_2
XFILLER_0_26_406 VPWR VGND VPWR VGND sky130_ef_sc_hd__decap_12
XFILLER_0_81_534 VGND VGND VPWR VPWR sky130_fd_sc_hd__fill_1
XFILLER_0_53_225 VPWR VGND VPWR VGND sky130_ef_sc_hd__decap_12
XFILLER_0_1_517 VPWR VGND VPWR VGND sky130_ef_sc_hd__decap_12
XFILLER_0_67_38 VGND VGND VPWR VPWR sky130_fd_sc_hd__decap_3
XANTENNA__3152__A1 _0691_ VGND VGND VPWR VPWR sky130_fd_sc_hd__diode_2
XFILLER_0_83_15 VPWR VGND VPWR VGND sky130_ef_sc_hd__decap_12
XFILLER_0_88_111 VGND VGND VPWR VPWR sky130_fd_sc_hd__fill_1
XFILLER_0_16_53 VPWR VGND VPWR VGND sky130_ef_sc_hd__decap_12
XFILLER_0_76_317 VGND VGND VPWR VPWR sky130_fd_sc_hd__fill_2
XFILLER_0_76_328 VPWR VGND VPWR VGND sky130_ef_sc_hd__decap_12
XFILLER_0_16_97 VGND VGND VPWR VPWR sky130_fd_sc_hd__fill_2
XTAP_TAPCELL_ROW_45_662 VGND VPWR sky130_fd_sc_hd__tapvpwrvgnd_1
XANTENNA_clkbuf_leaf_44_clk_A clknet_3_6__leaf_clk VGND VGND VPWR VPWR sky130_fd_sc_hd__diode_2
X_2953_ _0638_ VGND VGND VPWR VPWR _0024_ sky130_fd_sc_hd__inv_2
XFILLER_0_57_542 VGND VGND VPWR VPWR sky130_fd_sc_hd__decap_4
XTAP_TAPCELL_ROW_17_375 VGND VPWR sky130_fd_sc_hd__tapvpwrvgnd_1
XFILLER_0_72_545 VPWR VGND VPWR VGND sky130_ef_sc_hd__decap_12
XFILLER_0_4_300 VGND VGND VPWR VPWR sky130_fd_sc_hd__decap_8
XFILLER_0_29_299 VGND VGND VPWR VPWR sky130_fd_sc_hd__fill_2
X_2884_ _0578_ VGND VGND VPWR VPWR _0591_ sky130_fd_sc_hd__clkbuf_1
XFILLER_0_32_85 VGND VGND VPWR VPWR sky130_fd_sc_hd__fill_1
X_4623_ clknet_leaf_39_clk _0053_ net10 VGND VGND VPWR VPWR tree_instances\[14\].u_tree.tree_state\[3\]
+ sky130_fd_sc_hd__dfrtp_1
XFILLER_0_4_333 VPWR VGND VPWR VGND sky130_ef_sc_hd__decap_12
XANTENNA_clkbuf_leaf_59_clk_A clknet_3_4__leaf_clk VGND VGND VPWR VPWR sky130_fd_sc_hd__diode_2
XFILLER_0_44_269 VGND VGND VPWR VPWR sky130_fd_sc_hd__fill_1
X_4554_ clknet_leaf_66_clk _0275_ tree_instances\[0\].u_tree.rst_n VGND VGND VPWR
+ VPWR tree_instances\[7\].u_tree.pipeline_current_node\[0\]\[1\] sky130_fd_sc_hd__dfrtp_1
XFILLER_0_25_494 VGND VGND VPWR VPWR sky130_fd_sc_hd__fill_1
XFILLER_0_52_280 VGND VGND VPWR VPWR sky130_fd_sc_hd__decap_4
X_3505_ _1059_ VGND VGND VPWR VPWR _1060_ sky130_fd_sc_hd__clkbuf_1
X_4485_ clknet_leaf_61_clk _0225_ tree_instances\[0\].u_tree.rst_n VGND VGND VPWR
+ VPWR tree_instances\[4\].u_tree.frame_id_out\[1\] sky130_fd_sc_hd__dfrtp_1
XFILLER_0_0_561 VPWR VGND VPWR VGND sky130_ef_sc_hd__decap_12
X_3436_ tree_instances\[3\].u_tree.tree_state\[0\] _1871_ VGND VGND VPWR VPWR _1016_
+ sky130_fd_sc_hd__nand2_1
XANTENNA__3143__A1 _0704_ VGND VGND VPWR VPWR sky130_fd_sc_hd__diode_2
X_3367_ _1881_ VGND VGND VPWR VPWR _0980_ sky130_fd_sc_hd__clkbuf_1
XANTENNA__4817__SET_B net11 VGND VGND VPWR VPWR sky130_fd_sc_hd__diode_2
X_2318_ tree_instances\[7\].u_tree.tree_state\[3\] VGND VGND VPWR VPWR _1685_ sky130_fd_sc_hd__inv_2
X_3298_ _2155_ _0936_ VGND VGND VPWR VPWR _0938_ sky130_fd_sc_hd__and2_1
XANTENNA__4176__S _0018_ VGND VGND VPWR VPWR sky130_fd_sc_hd__diode_2
XTAP_TAPCELL_ROW_0_210 VGND VPWR sky130_fd_sc_hd__tapvpwrvgnd_1
X_2249_ tree_instances\[17\].u_tree.pipeline_current_node\[0\]\[2\] VGND VGND VPWR
+ VPWR _1625_ sky130_fd_sc_hd__clkbuf_1
XTAP_TAPCELL_ROW_84_1045 VGND VPWR sky130_fd_sc_hd__tapvpwrvgnd_1
XTAP_TAPCELL_ROW_71_919 VGND VPWR sky130_fd_sc_hd__tapvpwrvgnd_1
XANTENNA__4634__RESET_B tree_instances\[0\].u_tree.rst_n VGND VGND VPWR VPWR sky130_fd_sc_hd__diode_2
XFILLER_0_94_136 VGND VGND VPWR VPWR sky130_fd_sc_hd__fill_1
XFILLER_0_82_309 VGND VGND VPWR VPWR sky130_fd_sc_hd__decap_8
XFILLER_0_35_214 VGND VGND VPWR VPWR sky130_fd_sc_hd__decap_8
XFILLER_0_35_236 VGND VGND VPWR VPWR sky130_fd_sc_hd__fill_2
XTAP_TAPCELL_ROW_95_1163 VGND VPWR sky130_fd_sc_hd__tapvpwrvgnd_1
XFILLER_0_31_486 VGND VGND VPWR VPWR sky130_fd_sc_hd__decap_8
XFILLER_0_9_3 VPWR VGND VPWR VGND sky130_ef_sc_hd__decap_12
XANTENNA__3134__A1 _0694_ VGND VGND VPWR VPWR sky130_fd_sc_hd__diode_2
XANTENNA__3134__B2 _0702_ VGND VGND VPWR VPWR sky130_fd_sc_hd__diode_2
XTAP_TAPCELL_ROW_59_798 VGND VPWR sky130_fd_sc_hd__tapvpwrvgnd_1
XANTENNA_clkbuf_3_1__f_clk_A clknet_0_clk VGND VGND VPWR VPWR sky130_fd_sc_hd__diode_2
XFILLER_0_53_29 VGND VGND VPWR VPWR sky130_fd_sc_hd__fill_2
XANTENNA__4375__RESET_B net13 VGND VGND VPWR VPWR sky130_fd_sc_hd__diode_2
XFILLER_0_85_125 VPWR VGND VPWR VGND sky130_ef_sc_hd__decap_12
XFILLER_0_58_328 VGND VGND VPWR VPWR sky130_fd_sc_hd__decap_8
XFILLER_0_85_169 VPWR VGND VPWR VGND sky130_ef_sc_hd__decap_12
XTAP_TAPCELL_ROW_14_345 VGND VPWR sky130_fd_sc_hd__tapvpwrvgnd_1
XFILLER_0_39_564 VGND VGND VPWR VPWR sky130_fd_sc_hd__decap_8
XTAP_TAPCELL_ROW_42_632 VGND VPWR sky130_fd_sc_hd__tapvpwrvgnd_1
XFILLER_0_54_501 VPWR VGND VPWR VGND sky130_ef_sc_hd__decap_12
XFILLER_0_81_353 VGND VGND VPWR VPWR sky130_fd_sc_hd__decap_8
XFILLER_0_78_15 VGND VGND VPWR VPWR sky130_fd_sc_hd__decap_6
XFILLER_0_78_37 VGND VGND VPWR VPWR sky130_fd_sc_hd__decap_3
XFILLER_0_22_464 VGND VGND VPWR VPWR sky130_fd_sc_hd__fill_1
XFILLER_0_22_475 VGND VGND VPWR VPWR sky130_fd_sc_hd__fill_1
X_4270_ _1517_ VGND VGND VPWR VPWR _0540_ sky130_fd_sc_hd__clkbuf_1
X_3221_ _0891_ VGND VGND VPWR VPWR _0117_ sky130_fd_sc_hd__clkbuf_1
XFILLER_0_94_58 VGND VGND VPWR VPWR sky130_fd_sc_hd__decap_4
X_3152_ _0691_ tree_instances\[12\].u_tree.frame_id_out\[3\] tree_instances\[12\].u_tree.prediction_valid
+ _0820_ _0823_ VGND VGND VPWR VPWR _0824_ sky130_fd_sc_hd__o2111a_1
X_3083_ _0691_ tree_instances\[19\].u_tree.frame_id_out\[3\] _0751_ _0754_ VGND VGND
+ VPWR VPWR _0755_ sky130_fd_sc_hd__o211ai_1
XFILLER_0_91_117 VGND VGND VPWR VPWR sky130_fd_sc_hd__fill_1
X_3985_ tree_instances\[14\].u_tree.tree_state\[1\] tree_instances\[14\].u_tree.tree_state\[2\]
+ _0636_ VGND VGND VPWR VPWR _1353_ sky130_fd_sc_hd__or3_1
XFILLER_0_64_309 VGND VGND VPWR VPWR sky130_fd_sc_hd__decap_3
XFILLER_0_91_128 VGND VGND VPWR VPWR sky130_fd_sc_hd__fill_2
X_2936_ _0627_ VGND VGND VPWR VPWR _0032_ sky130_fd_sc_hd__inv_2
XFILLER_0_17_225 VPWR VGND VPWR VGND sky130_ef_sc_hd__decap_12
X_2867_ _2162_ VGND VGND VPWR VPWR _0574_ sky130_fd_sc_hd__clkbuf_1
XFILLER_0_87_3 VGND VGND VPWR VPWR sky130_fd_sc_hd__decap_6
X_4606_ clknet_leaf_68_clk _0321_ net9 VGND VGND VPWR VPWR tree_instances\[9\].u_tree.pipeline_current_node\[0\]\[7\]
+ sky130_fd_sc_hd__dfrtp_1
XFILLER_0_13_431 VGND VGND VPWR VPWR sky130_fd_sc_hd__fill_1
XFILLER_0_4_152 VGND VGND VPWR VPWR sky130_fd_sc_hd__decap_8
X_2798_ _2102_ VGND VGND VPWR VPWR _2103_ sky130_fd_sc_hd__clkbuf_1
X_4537_ clknet_leaf_23_clk _0267_ net11 VGND VGND VPWR VPWR tree_instances\[6\].u_tree.frame_id_out\[0\]
+ sky130_fd_sc_hd__dfrtp_1
XFILLER_0_13_475 VGND VGND VPWR VPWR sky130_fd_sc_hd__decap_6
XFILLER_0_7_51 VGND VGND VPWR VPWR sky130_fd_sc_hd__decap_4
XFILLER_0_7_84 VGND VGND VPWR VPWR sky130_fd_sc_hd__fill_2
X_4468_ clknet_leaf_61_clk _0099_ tree_instances\[0\].u_tree.rst_n VGND VGND VPWR
+ VPWR tree_instances\[3\].u_tree.prediction_valid sky130_fd_sc_hd__dfrtp_1
X_3419_ _1007_ VGND VGND VPWR VPWR _0199_ sky130_fd_sc_hd__clkbuf_1
XANTENNA__3116__B2 _0657_ VGND VGND VPWR VPWR sky130_fd_sc_hd__diode_2
X_4399_ clknet_leaf_46_clk _0146_ net13 VGND VGND VPWR VPWR tree_instances\[17\].u_tree.pipeline_valid\[0\]
+ sky130_fd_sc_hd__dfrtp_1
XANTENNA__4886__RESET_B net11 VGND VGND VPWR VPWR sky130_fd_sc_hd__diode_2
XTAP_TAPCELL_ROW_56_768 VGND VPWR sky130_fd_sc_hd__tapvpwrvgnd_1
XFILLER_0_67_169 VGND VGND VPWR VPWR sky130_fd_sc_hd__decap_3
XFILLER_0_36_545 VGND VGND VPWR VPWR sky130_fd_sc_hd__decap_3
XTAP_TAPCELL_ROW_11_315 VGND VPWR sky130_fd_sc_hd__tapvpwrvgnd_1
XANTENNA__3014__A _0685_ VGND VGND VPWR VPWR sky130_fd_sc_hd__diode_2
XANTENNA__4556__RESET_B net9 VGND VGND VPWR VPWR sky130_fd_sc_hd__diode_2
XTAP_TAPCELL_ROW_27_481 VGND VPWR sky130_fd_sc_hd__tapvpwrvgnd_1
XFILLER_0_39_350 VGND VGND VPWR VPWR sky130_fd_sc_hd__decap_8
XFILLER_0_39_361 VGND VGND VPWR VPWR sky130_fd_sc_hd__fill_2
XFILLER_0_46_309 VGND VGND VPWR VPWR sky130_fd_sc_hd__decap_3
XFILLER_0_13_43 VGND VGND VPWR VPWR sky130_fd_sc_hd__decap_4
X_3770_ tree_instances\[9\].u_tree.frame_id_out\[3\] tree_instances\[9\].u_tree.pipeline_frame_id\[0\]\[3\]
+ _1649_ VGND VGND VPWR VPWR _1227_ sky130_fd_sc_hd__mux2_1
XFILLER_0_66_191 VGND VGND VPWR VPWR sky130_fd_sc_hd__fill_2
X_2721_ tree_instances\[11\].u_tree.pipeline_current_node\[0\]\[6\] VGND VGND VPWR
+ VPWR _2037_ sky130_fd_sc_hd__clkbuf_1
XFILLER_0_54_342 VPWR VGND VPWR VGND sky130_ef_sc_hd__decap_12
XFILLER_0_54_375 VGND VGND VPWR VPWR sky130_fd_sc_hd__decap_8
X_2652_ _1973_ VGND VGND VPWR VPWR _1974_ sky130_fd_sc_hd__clkbuf_1
X_2583_ tree_instances\[1\].u_tree.pipeline_current_node\[0\]\[0\] VGND VGND VPWR
+ VPWR _1916_ sky130_fd_sc_hd__clkbuf_1
XFILLER_0_1_111 VGND VGND VPWR VPWR sky130_fd_sc_hd__fill_1
X_4322_ _1908_ _1437_ _0634_ tree_instances\[20\].u_tree.ready_for_next VGND VGND
+ VPWR VPWR _0566_ sky130_fd_sc_hd__a22o_1
X_4253_ _1992_ _1502_ VGND VGND VPWR VPWR _1509_ sky130_fd_sc_hd__and2_1
X_3204_ tree_instances\[5\].u_tree.frame_id_out\[1\] _0650_ VGND VGND VPWR VPWR _0876_
+ sky130_fd_sc_hd__and2b_1
X_4184_ tree_instances\[17\].u_tree.frame_id_out\[2\] tree_instances\[17\].u_tree.pipeline_frame_id\[0\]\[2\]
+ _1827_ VGND VGND VPWR VPWR _1473_ sky130_fd_sc_hd__mux2_1
X_3135_ tree_instances\[3\].u_tree.prediction_valid _0801_ _0804_ _0806_ VGND VGND
+ VPWR VPWR _0807_ sky130_fd_sc_hd__and4_1
XFILLER_0_96_209 VPWR VGND VPWR VGND sky130_ef_sc_hd__decap_12
X_3066_ _0647_ tree_instances\[17\].u_tree.frame_id_out\[0\] _0736_ _0737_ tree_instances\[17\].u_tree.prediction_valid
+ VGND VGND VPWR VPWR _0738_ sky130_fd_sc_hd__o221a_1
XFILLER_0_54_72 VGND VGND VPWR VPWR sky130_fd_sc_hd__fill_1
XTAP_TAPCELL_ROW_81_1015 VGND VPWR sky130_fd_sc_hd__tapvpwrvgnd_1
XTAP_TAPCELL_ROW_53_738 VGND VPWR sky130_fd_sc_hd__tapvpwrvgnd_1
XFILLER_0_77_489 VPWR VGND VPWR VGND sky130_ef_sc_hd__decap_12
XFILLER_0_18_501 VGND VGND VPWR VPWR sky130_fd_sc_hd__decap_3
XFILLER_0_49_169 VGND VGND VPWR VPWR sky130_fd_sc_hd__fill_2
XFILLER_0_18_545 VPWR VGND VPWR VGND sky130_ef_sc_hd__decap_12
X_3968_ tree_instances\[13\].u_tree.pipeline_frame_id\[0\]\[3\] _1192_ _0010_ VGND
+ VGND VPWR VPWR _1345_ sky130_fd_sc_hd__mux2_1
X_2919_ tree_instances\[10\].u_tree.tree_state\[0\] VGND VGND VPWR VPWR _0617_ sky130_fd_sc_hd__inv_2
XFILLER_0_45_353 VGND VGND VPWR VPWR sky130_fd_sc_hd__fill_2
X_3899_ _1566_ _1293_ VGND VGND VPWR VPWR _1302_ sky130_fd_sc_hd__and2_1
XFILLER_0_72_172 VGND VGND VPWR VPWR sky130_fd_sc_hd__decap_4
XFILLER_0_72_150 VGND VGND VPWR VPWR sky130_fd_sc_hd__decap_8
XFILLER_0_33_515 VGND VGND VPWR VPWR sky130_fd_sc_hd__decap_3
XFILLER_0_45_375 VPWR VGND VPWR VGND sky130_ef_sc_hd__decap_12
XFILLER_0_60_345 VGND VGND VPWR VPWR sky130_fd_sc_hd__fill_2
XFILLER_0_5_461 VPWR VGND VPWR VGND sky130_ef_sc_hd__decap_12
XFILLER_0_20_209 VGND VGND VPWR VPWR sky130_fd_sc_hd__decap_3
XTAP_TAPCELL_ROW_92_1133 VGND VPWR sky130_fd_sc_hd__tapvpwrvgnd_1
XFILLER_0_95_231 VPWR VGND VPWR VGND sky130_ef_sc_hd__decap_12
XFILLER_0_95_264 VPWR VGND VPWR VGND sky130_ef_sc_hd__decap_12
XFILLER_0_28_309 VPWR VGND VPWR VGND sky130_ef_sc_hd__decap_12
XTAP_TAPCELL_ROW_24_451 VGND VPWR sky130_fd_sc_hd__tapvpwrvgnd_1
XFILLER_0_36_397 VGND VGND VPWR VPWR sky130_fd_sc_hd__fill_1
XFILLER_0_63_183 VGND VGND VPWR VPWR sky130_fd_sc_hd__fill_1
XANTENNA__3009__A tree_instances\[0\].u_tree.frame_id_in\[4\] VGND VGND VPWR VPWR
+ sky130_fd_sc_hd__diode_2
XANTENNA__4737__RESET_B net11 VGND VGND VPWR VPWR sky130_fd_sc_hd__diode_2
XANTENNA_hold1_A rst_n VGND VGND VPWR VPWR sky130_fd_sc_hd__diode_2
XANTENNA__4390__RESET_B net11 VGND VGND VPWR VPWR sky130_fd_sc_hd__diode_2
XFILLER_0_59_489 VPWR VGND VPWR VGND sky130_ef_sc_hd__decap_12
X_4871_ clknet_leaf_42_clk _0015_ net10 VGND VGND VPWR VPWR tree_instances\[16\].u_tree.tree_state\[1\]
+ sky130_fd_sc_hd__dfrtp_1
X_3822_ _1668_ _1253_ _0040_ tree_instances\[8\].u_tree.pipeline_valid\[0\] VGND VGND
+ VPWR VPWR _0356_ sky130_fd_sc_hd__o2bb2a_1
XTAP_TAPCELL_ROW_50_708 VGND VPWR sky130_fd_sc_hd__tapvpwrvgnd_1
XFILLER_0_6_203 VGND VGND VPWR VPWR sky130_fd_sc_hd__fill_1
XFILLER_0_27_353 VPWR VGND VPWR VGND sky130_ef_sc_hd__decap_12
X_3753_ _1218_ VGND VGND VPWR VPWR _0322_ sky130_fd_sc_hd__clkbuf_1
XFILLER_0_54_172 VGND VGND VPWR VPWR sky130_fd_sc_hd__fill_1
X_2704_ _2011_ VGND VGND VPWR VPWR _2023_ sky130_fd_sc_hd__clkbuf_1
X_3684_ tree_instances\[8\].u_tree.tree_state\[2\] tree_instances\[8\].u_tree.tree_state\[1\]
+ _0612_ VGND VGND VPWR VPWR _1178_ sky130_fd_sc_hd__or3_1
XFILLER_0_15_559 VGND VGND VPWR VPWR sky130_fd_sc_hd__fill_1
XFILLER_0_40_85 VPWR VGND VPWR VGND sky130_ef_sc_hd__decap_12
XFILLER_0_54_183 VPWR VGND VPWR VGND sky130_ef_sc_hd__decap_12
X_2635_ tree_instances\[18\].u_tree.pipeline_current_node\[0\]\[5\] VGND VGND VPWR
+ VPWR _1961_ sky130_fd_sc_hd__buf_1
XFILLER_0_2_475 VGND VGND VPWR VPWR sky130_fd_sc_hd__fill_1
X_2566_ _1900_ _1903_ VGND VGND VPWR VPWR _1904_ sky130_fd_sc_hd__nor2_1
XFILLER_0_10_253 VGND VGND VPWR VPWR sky130_fd_sc_hd__fill_2
X_4305_ _1535_ VGND VGND VPWR VPWR _0557_ sky130_fd_sc_hd__clkbuf_1
XANTENNA__4478__RESET_B net9 VGND VGND VPWR VPWR sky130_fd_sc_hd__diode_2
X_2497_ tree_instances\[3\].u_tree.pipeline_current_node\[0\]\[5\] VGND VGND VPWR
+ VPWR _1843_ sky130_fd_sc_hd__clkbuf_1
XANTENNA__4407__RESET_B net13 VGND VGND VPWR VPWR sky130_fd_sc_hd__diode_2
XFILLER_0_4_41 VPWR VGND VPWR VGND sky130_ef_sc_hd__decap_12
X_4236_ _1670_ _1499_ _0020_ tree_instances\[18\].u_tree.pipeline_valid\[0\] VGND
+ VGND VPWR VPWR _0524_ sky130_fd_sc_hd__o2bb2a_1
XFILLER_0_4_85 VGND VGND VPWR VPWR sky130_fd_sc_hd__fill_2
X_4167_ _1464_ VGND VGND VPWR VPWR _0490_ sky130_fd_sc_hd__clkbuf_1
X_3118_ _0714_ tree_instances\[4\].u_tree.frame_id_out\[2\] tree_instances\[4\].u_tree.frame_id_out\[4\]
+ _0697_ VGND VGND VPWR VPWR _0790_ sky130_fd_sc_hd__a22o_1
X_4098_ tree_instances\[16\].u_tree.pipeline_frame_id\[0\]\[3\] _0678_ _0016_ VGND
+ VGND VPWR VPWR _1412_ sky130_fd_sc_hd__mux2_1
X_3049_ _0687_ _0700_ _0712_ _0720_ VGND VGND VPWR VPWR _0721_ sky130_fd_sc_hd__o211a_1
XTAP_TAPCELL_ROW_38_587 VGND VPWR sky130_fd_sc_hd__tapvpwrvgnd_1
XANTENNA__4184__S _1827_ VGND VGND VPWR VPWR sky130_fd_sc_hd__diode_2
XFILLER_0_77_253 VGND VGND VPWR VPWR sky130_fd_sc_hd__fill_2
XFILLER_0_92_234 VPWR VGND VPWR VGND sky130_ef_sc_hd__decap_12
XTAP_TAPCELL_ROW_21_421 VGND VPWR sky130_fd_sc_hd__tapvpwrvgnd_1
XFILLER_0_45_172 VPWR VGND VPWR VGND sky130_ef_sc_hd__decap_12
XFILLER_0_18_397 VGND VGND VPWR VPWR sky130_fd_sc_hd__fill_1
XFILLER_0_60_197 VGND VGND VPWR VPWR sky130_fd_sc_hd__decap_4
XFILLER_0_60_175 VPWR VGND VPWR VGND sky130_ef_sc_hd__decap_12
XANTENNA__4830__RESET_B net10 VGND VGND VPWR VPWR sky130_fd_sc_hd__diode_2
XFILLER_0_88_507 VPWR VGND VPWR VGND sky130_ef_sc_hd__decap_12
XFILLER_0_68_253 VGND VGND VPWR VPWR sky130_fd_sc_hd__decap_8
XFILLER_0_68_297 VGND VGND VPWR VPWR sky130_fd_sc_hd__fill_2
XANTENNA__3011__B _0645_ VGND VGND VPWR VPWR sky130_fd_sc_hd__diode_2
XFILLER_0_28_117 VPWR VGND VPWR VGND sky130_ef_sc_hd__decap_12
XFILLER_0_64_481 VPWR VGND VPWR VGND sky130_ef_sc_hd__decap_12
XFILLER_0_64_470 VGND VGND VPWR VPWR sky130_fd_sc_hd__decap_3
XFILLER_0_24_301 VGND VGND VPWR VPWR sky130_fd_sc_hd__decap_6
XFILLER_0_10_77 VGND VGND VPWR VPWR sky130_fd_sc_hd__decap_6
X_2420_ tree_instances\[16\].u_tree.pipeline_current_node\[0\]\[0\] VGND VGND VPWR
+ VPWR _1774_ sky130_fd_sc_hd__clkbuf_1
XFILLER_0_86_26 VGND VGND VPWR VPWR sky130_fd_sc_hd__fill_2
XFILLER_0_86_59 VGND VGND VPWR VPWR sky130_fd_sc_hd__fill_1
X_2351_ _1713_ VGND VGND VPWR VPWR _1714_ sky130_fd_sc_hd__clkbuf_1
XFILLER_0_20_573 VGND VGND VPWR VPWR sky130_fd_sc_hd__fill_1
XANTENNA__4571__RESET_B net9 VGND VGND VPWR VPWR sky130_fd_sc_hd__diode_2
X_2282_ _1652_ VGND VGND VPWR VPWR _1653_ sky130_fd_sc_hd__clkbuf_1
XANTENNA__4500__RESET_B net13 VGND VGND VPWR VPWR sky130_fd_sc_hd__diode_2
X_4021_ tree_instances\[14\].u_tree.frame_id_out\[3\] tree_instances\[14\].u_tree.pipeline_frame_id\[0\]\[3\]
+ _1889_ VGND VGND VPWR VPWR _1372_ sky130_fd_sc_hd__mux2_1
XFILLER_0_59_220 VGND VGND VPWR VPWR sky130_fd_sc_hd__decap_4
XFILLER_0_87_573 VGND VGND VPWR VPWR sky130_fd_sc_hd__fill_1
XANTENNA__3202__A _0726_ VGND VGND VPWR VPWR sky130_fd_sc_hd__diode_2
XFILLER_0_74_201 VGND VGND VPWR VPWR sky130_fd_sc_hd__decap_8
XFILLER_0_59_275 VGND VGND VPWR VPWR sky130_fd_sc_hd__decap_4
XTAP_TAPCELL_ROW_35_557 VGND VPWR sky130_fd_sc_hd__tapvpwrvgnd_1
X_4854_ clknet_leaf_43_clk _0535_ net13 VGND VGND VPWR VPWR tree_instances\[19\].u_tree.pipeline_frame_id\[0\]\[0\]
+ sky130_fd_sc_hd__dfrtp_1
XFILLER_0_51_51 VGND VGND VPWR VPWR sky130_fd_sc_hd__decap_4
XFILLER_0_62_429 VGND VGND VPWR VPWR sky130_fd_sc_hd__fill_1
X_4785_ clknet_leaf_43_clk _0473_ net13 VGND VGND VPWR VPWR tree_instances\[16\].u_tree.pipeline_frame_id\[0\]\[2\]
+ sky130_fd_sc_hd__dfrtp_1
X_3805_ _1245_ VGND VGND VPWR VPWR _0347_ sky130_fd_sc_hd__clkbuf_1
XFILLER_0_15_323 VGND VGND VPWR VPWR sky130_fd_sc_hd__fill_2
X_3736_ _1204_ _1209_ VGND VGND VPWR VPWR _1210_ sky130_fd_sc_hd__and2_1
Xclkload60 clknet_leaf_35_clk VGND VGND VPWR VPWR clkload60/Y sky130_fd_sc_hd__clkinvlp_4
X_3667_ tree_instances\[0\].u_tree.frame_id_in\[4\] VGND VGND VPWR VPWR _1168_ sky130_fd_sc_hd__clkbuf_4
XANTENNA__4659__RESET_B net12 VGND VGND VPWR VPWR sky130_fd_sc_hd__diode_2
XFILLER_0_42_197 VPWR VGND VPWR VGND sky130_ef_sc_hd__decap_12
X_2618_ _1942_ _1945_ VGND VGND VPWR VPWR _1946_ sky130_fd_sc_hd__or2_1
X_3598_ _1123_ VGND VGND VPWR VPWR _0262_ sky130_fd_sc_hd__clkbuf_1
XFILLER_0_2_261 VGND VGND VPWR VPWR sky130_fd_sc_hd__decap_3
X_2549_ tree_instances\[14\].u_tree.tree_state\[3\] VGND VGND VPWR VPWR _1889_ sky130_fd_sc_hd__buf_2
XFILLER_0_11_573 VGND VGND VPWR VPWR sky130_fd_sc_hd__fill_1
XFILLER_0_76_70 VGND VGND VPWR VPWR sky130_fd_sc_hd__fill_2
X_4219_ tree_instances\[18\].u_tree.pipeline_frame_id\[0\]\[3\] _0678_ _0020_ VGND
+ VGND VPWR VPWR _1491_ sky130_fd_sc_hd__mux2_1
XTAP_TAPCELL_ROW_87_1076 VGND VPWR sky130_fd_sc_hd__tapvpwrvgnd_1
XFILLER_0_78_573 VGND VGND VPWR VPWR sky130_fd_sc_hd__fill_1
XFILLER_0_38_415 VGND VGND VPWR VPWR sky130_fd_sc_hd__fill_2
XFILLER_0_65_256 VGND VGND VPWR VPWR sky130_fd_sc_hd__fill_2
XFILLER_0_65_234 VGND VGND VPWR VPWR sky130_fd_sc_hd__fill_2
XFILLER_0_46_470 VGND VGND VPWR VPWR sky130_fd_sc_hd__decap_4
XFILLER_0_61_462 VGND VGND VPWR VPWR sky130_fd_sc_hd__decap_3
XFILLER_0_33_131 VGND VGND VPWR VPWR sky130_fd_sc_hd__decap_6
XFILLER_0_33_153 VPWR VGND VPWR VGND sky130_ef_sc_hd__decap_12
XFILLER_0_0_209 VPWR VGND VPWR VGND sky130_ef_sc_hd__decap_12
XFILLER_0_21_337 VGND VGND VPWR VPWR sky130_fd_sc_hd__fill_1
XFILLER_0_56_29 VPWR VGND VPWR VGND sky130_ef_sc_hd__decap_12
XTAP_TAPCELL_ROW_6_271 VGND VPWR sky130_fd_sc_hd__tapvpwrvgnd_1
Xload_slew11 net13 VGND VGND VPWR VPWR net11 sky130_fd_sc_hd__clkbuf_16
XANTENNA__3022__A _0646_ VGND VGND VPWR VPWR sky130_fd_sc_hd__diode_2
XFILLER_0_69_573 VGND VGND VPWR VPWR sky130_fd_sc_hd__fill_1
XFILLER_0_8_309 VGND VGND VPWR VPWR sky130_fd_sc_hd__decap_8
XTAP_TAPCELL_ROW_32_527 VGND VPWR sky130_fd_sc_hd__tapvpwrvgnd_1
XFILLER_0_44_418 VGND VGND VPWR VPWR sky130_fd_sc_hd__fill_2
XFILLER_0_56_278 VGND VGND VPWR VPWR sky130_fd_sc_hd__fill_1
XFILLER_0_56_289 VPWR VGND VPWR VGND sky130_ef_sc_hd__decap_12
XFILLER_0_71_237 VGND VGND VPWR VPWR sky130_fd_sc_hd__decap_3
X_4570_ clknet_leaf_62_clk _0291_ net9 VGND VGND VPWR VPWR tree_instances\[7\].u_tree.frame_id_out\[3\]
+ sky130_fd_sc_hd__dfrtp_1
XFILLER_0_24_120 VGND VGND VPWR VPWR sky130_fd_sc_hd__fill_2
XFILLER_0_21_65 VGND VGND VPWR VPWR sky130_fd_sc_hd__decap_8
X_3521_ _1072_ _1054_ VGND VGND VPWR VPWR _1073_ sky130_fd_sc_hd__and2_1
XFILLER_0_24_175 VGND VGND VPWR VPWR sky130_fd_sc_hd__fill_2
XFILLER_0_24_197 VGND VGND VPWR VPWR sky130_fd_sc_hd__fill_2
XANTENNA_clkbuf_leaf_3_clk_A clknet_3_0__leaf_clk VGND VGND VPWR VPWR sky130_fd_sc_hd__diode_2
XANTENNA__4752__RESET_B net10 VGND VGND VPWR VPWR sky130_fd_sc_hd__diode_2
XFILLER_0_52_473 VGND VGND VPWR VPWR sky130_fd_sc_hd__decap_3
X_3452_ _1906_ _1029_ VGND VGND VPWR VPWR _1030_ sky130_fd_sc_hd__and2_1
X_2403_ _1759_ VGND VGND VPWR VPWR _1760_ sky130_fd_sc_hd__clkbuf_1
X_3383_ _0988_ VGND VGND VPWR VPWR _0182_ sky130_fd_sc_hd__clkbuf_1
X_2334_ _1698_ tree_instances\[15\].u_tree.tree_state\[2\] VGND VGND VPWR VPWR _1699_
+ sky130_fd_sc_hd__and2b_1
X_2265_ _1639_ VGND VGND VPWR VPWR _1640_ sky130_fd_sc_hd__clkbuf_1
X_4004_ _1363_ VGND VGND VPWR VPWR _0428_ sky130_fd_sc_hd__clkbuf_1
X_2196_ tree_instances\[13\].u_tree.tree_state\[0\] _1576_ _1577_ VGND VGND VPWR VPWR
+ _0050_ sky130_fd_sc_hd__a21o_1
XFILLER_0_79_337 VGND VGND VPWR VPWR sky130_fd_sc_hd__fill_2
XFILLER_0_79_326 VGND VGND VPWR VPWR sky130_fd_sc_hd__fill_2
XTAP_TAPCELL_ROW_48_693 VGND VPWR sky130_fd_sc_hd__tapvpwrvgnd_1
XFILLER_0_47_201 VPWR VGND VPWR VGND sky130_ef_sc_hd__decap_12
XFILLER_0_35_429 VPWR VGND VPWR VGND sky130_ef_sc_hd__decap_12
X_4837_ clknet_leaf_46_clk _0519_ net13 VGND VGND VPWR VPWR tree_instances\[18\].u_tree.frame_id_out\[1\]
+ sky130_fd_sc_hd__dfrtp_1
X_4768_ clknet_leaf_40_clk _0066_ net10 VGND VGND VPWR VPWR tree_instances\[20\].u_tree.tree_state\[3\]
+ sky130_fd_sc_hd__dfrtp_1
XANTENNA__4493__RESET_B net11 VGND VGND VPWR VPWR sky130_fd_sc_hd__diode_2
X_3719_ tree_instances\[8\].u_tree.frame_id_out\[2\] tree_instances\[8\].u_tree.pipeline_frame_id\[0\]\[2\]
+ _1668_ VGND VGND VPWR VPWR _1197_ sky130_fd_sc_hd__mux2_1
X_4699_ clknet_leaf_71_clk _0402_ net9 VGND VGND VPWR VPWR tree_instances\[13\].u_tree.pipeline_current_node\[0\]\[3\]
+ sky130_fd_sc_hd__dfrtp_1
XANTENNA__4422__RESET_B tree_instances\[0\].u_tree.rst_n VGND VGND VPWR VPWR sky130_fd_sc_hd__diode_2
XFILLER_0_15_197 VGND VGND VPWR VPWR sky130_fd_sc_hd__decap_8
XANTENNA__3107__A _0657_ VGND VGND VPWR VPWR sky130_fd_sc_hd__diode_2
XTAP_TAPCELL_ROW_3_241 VGND VPWR sky130_fd_sc_hd__tapvpwrvgnd_1
XFILLER_0_78_381 VPWR VGND VPWR VGND sky130_ef_sc_hd__decap_12
XFILLER_0_66_510 VPWR VGND VPWR VGND sky130_ef_sc_hd__decap_12
XFILLER_0_93_340 VPWR VGND VPWR VGND sky130_ef_sc_hd__decap_12
XFILLER_0_66_554 VPWR VGND VPWR VGND sky130_ef_sc_hd__decap_12
XFILLER_0_38_234 VPWR VGND VPWR VGND sky130_ef_sc_hd__decap_12
XFILLER_0_81_513 VGND VGND VPWR VPWR sky130_fd_sc_hd__fill_2
XFILLER_0_81_502 VGND VGND VPWR VPWR sky130_fd_sc_hd__fill_2
XFILLER_0_26_418 VGND VGND VPWR VPWR sky130_fd_sc_hd__fill_2
XFILLER_0_53_237 VPWR VGND VPWR VGND sky130_ef_sc_hd__decap_12
XFILLER_0_1_529 VPWR VGND VPWR VGND sky130_ef_sc_hd__decap_12
XFILLER_0_21_167 VGND VGND VPWR VPWR sky130_fd_sc_hd__fill_1
XFILLER_0_83_27 VPWR VGND VPWR VGND sky130_ef_sc_hd__decap_12
XFILLER_0_16_32 VPWR VGND VPWR VGND sky130_ef_sc_hd__decap_12
XFILLER_0_16_65 VGND VGND VPWR VPWR sky130_fd_sc_hd__decap_8
XTAP_TAPCELL_ROW_45_663 VGND VPWR sky130_fd_sc_hd__tapvpwrvgnd_1
X_2952_ _0637_ _1933_ VGND VGND VPWR VPWR _0638_ sky130_fd_sc_hd__or2_1
XTAP_TAPCELL_ROW_17_376 VGND VPWR sky130_fd_sc_hd__tapvpwrvgnd_1
XFILLER_0_29_234 VGND VGND VPWR VPWR sky130_fd_sc_hd__decap_6
XFILLER_0_32_20 VGND VGND VPWR VPWR sky130_fd_sc_hd__decap_4
XFILLER_0_84_351 VPWR VGND VPWR VGND sky130_ef_sc_hd__decap_12
XFILLER_0_72_513 VGND VGND VPWR VPWR sky130_fd_sc_hd__fill_1
XFILLER_0_29_267 VGND VGND VPWR VPWR sky130_fd_sc_hd__fill_2
XFILLER_0_72_557 VGND VGND VPWR VPWR sky130_fd_sc_hd__decap_4
X_2883_ _0589_ VGND VGND VPWR VPWR _0590_ sky130_fd_sc_hd__clkbuf_1
X_4622_ clknet_leaf_39_clk _0012_ net10 VGND VGND VPWR VPWR tree_instances\[14\].u_tree.tree_state\[2\]
+ sky130_fd_sc_hd__dfrtp_1
XFILLER_0_4_345 VPWR VGND VPWR VGND sky130_ef_sc_hd__decap_12
X_4553_ clknet_leaf_66_clk _0274_ tree_instances\[0\].u_tree.rst_n VGND VGND VPWR
+ VPWR tree_instances\[7\].u_tree.pipeline_current_node\[0\]\[0\] sky130_fd_sc_hd__dfrtp_1
XFILLER_0_40_421 VGND VGND VPWR VPWR sky130_fd_sc_hd__fill_2
X_3504_ tree_instances\[5\].u_tree.pipeline_current_node\[0\]\[2\] VGND VGND VPWR
+ VPWR _1059_ sky130_fd_sc_hd__clkbuf_1
X_4484_ clknet_leaf_63_clk _0224_ net9 VGND VGND VPWR VPWR tree_instances\[4\].u_tree.frame_id_out\[0\]
+ sky130_fd_sc_hd__dfrtp_1
XFILLER_0_12_178 VPWR VGND VPWR VGND sky130_ef_sc_hd__decap_12
X_3435_ _1015_ VGND VGND VPWR VPWR _0207_ sky130_fd_sc_hd__clkbuf_1
XFILLER_0_0_573 VGND VGND VPWR VPWR sky130_fd_sc_hd__fill_1
X_3366_ _0979_ VGND VGND VPWR VPWR _0174_ sky130_fd_sc_hd__clkbuf_1
XFILLER_0_57_50 VGND VGND VPWR VPWR sky130_fd_sc_hd__decap_6
X_3297_ _0937_ VGND VGND VPWR VPWR _0147_ sky130_fd_sc_hd__clkbuf_1
X_2317_ tree_instances\[7\].u_tree.tree_state\[2\] _1684_ tree_instances\[7\].u_tree.tree_state\[1\]
+ VGND VGND VPWR VPWR _0078_ sky130_fd_sc_hd__a21o_1
X_2248_ tree_instances\[17\].u_tree.pipeline_current_node\[0\]\[3\] VGND VGND VPWR
+ VPWR _1624_ sky130_fd_sc_hd__clkbuf_1
XFILLER_0_32_3 VPWR VGND VPWR VGND sky130_ef_sc_hd__decap_12
XTAP_TAPCELL_ROW_0_200 VGND VPWR sky130_fd_sc_hd__tapvpwrvgnd_1
XTAP_TAPCELL_ROW_0_211 VGND VPWR sky130_fd_sc_hd__tapvpwrvgnd_1
X_2179_ tree_instances\[12\].u_tree.pipeline_current_node\[0\]\[2\] VGND VGND VPWR
+ VPWR _1562_ sky130_fd_sc_hd__clkbuf_1
XFILLER_0_94_104 VGND VGND VPWR VPWR sky130_fd_sc_hd__decap_6
XTAP_TAPCELL_ROW_84_1046 VGND VPWR sky130_fd_sc_hd__tapvpwrvgnd_1
XFILLER_0_48_510 VGND VGND VPWR VPWR sky130_fd_sc_hd__decap_8
XFILLER_0_75_340 VGND VGND VPWR VPWR sky130_fd_sc_hd__fill_2
XANTENNA__4674__RESET_B net11 VGND VGND VPWR VPWR sky130_fd_sc_hd__diode_2
XFILLER_0_75_384 VGND VGND VPWR VPWR sky130_fd_sc_hd__decap_8
XFILLER_0_63_557 VGND VGND VPWR VPWR sky130_fd_sc_hd__decap_3
XFILLER_0_90_365 VGND VGND VPWR VPWR sky130_fd_sc_hd__decap_8
XANTENNA__4603__RESET_B net9 VGND VGND VPWR VPWR sky130_fd_sc_hd__diode_2
XFILLER_0_90_376 VGND VGND VPWR VPWR sky130_fd_sc_hd__decap_3
XFILLER_0_43_281 VGND VGND VPWR VPWR sky130_fd_sc_hd__decap_8
XFILLER_0_43_292 VGND VGND VPWR VPWR sky130_fd_sc_hd__decap_3
XFILLER_0_31_498 VGND VGND VPWR VPWR sky130_fd_sc_hd__fill_2
XANTENNA__3178__B_N _0660_ VGND VGND VPWR VPWR sky130_fd_sc_hd__diode_2
XTAP_TAPCELL_ROW_59_799 VGND VPWR sky130_fd_sc_hd__tapvpwrvgnd_1
XFILLER_0_85_137 VPWR VGND VPWR VGND sky130_ef_sc_hd__decap_12
XFILLER_0_66_351 VGND VGND VPWR VPWR sky130_fd_sc_hd__fill_2
XTAP_TAPCELL_ROW_14_346 VGND VPWR sky130_fd_sc_hd__tapvpwrvgnd_1
XTAP_TAPCELL_ROW_42_633 VGND VPWR sky130_fd_sc_hd__tapvpwrvgnd_1
XFILLER_0_54_513 VPWR VGND VPWR VGND sky130_ef_sc_hd__decap_12
XFILLER_0_26_226 VPWR VGND VPWR VGND sky130_ef_sc_hd__decap_12
XANTENNA__3070__A1 _0648_ VGND VGND VPWR VPWR sky130_fd_sc_hd__diode_2
XANTENNA__4344__RESET_B tree_instances\[0\].u_tree.rst_n VGND VGND VPWR VPWR sky130_fd_sc_hd__diode_2
XFILLER_0_78_27 VGND VGND VPWR VPWR sky130_fd_sc_hd__fill_1
XFILLER_0_1_337 VGND VGND VPWR VPWR sky130_fd_sc_hd__decap_3
XFILLER_0_94_15 VGND VGND VPWR VPWR sky130_fd_sc_hd__fill_2
XANTENNA__4322__A1 _1908_ VGND VGND VPWR VPWR sky130_fd_sc_hd__diode_2
X_3220_ _0887_ _0888_ _0890_ VGND VGND VPWR VPWR _0891_ sky130_fd_sc_hd__mux2_1
X_3151_ _0647_ tree_instances\[12\].u_tree.frame_id_out\[0\] _0821_ _0658_ _0822_
+ VGND VGND VPWR VPWR _0823_ sky130_fd_sc_hd__o221a_1
X_3082_ _0654_ _0748_ _0752_ _0753_ tree_instances\[19\].u_tree.prediction_valid VGND
+ VGND VPWR VPWR _0754_ sky130_fd_sc_hd__o221a_1
XFILLER_0_76_115 VGND VGND VPWR VPWR sky130_fd_sc_hd__fill_1
XFILLER_0_49_307 VGND VGND VPWR VPWR sky130_fd_sc_hd__decap_3
X_3984_ _1834_ _1352_ _0032_ tree_instances\[4\].u_tree.pipeline_valid\[0\] VGND VGND
+ VPWR VPWR _0419_ sky130_fd_sc_hd__o2bb2a_1
X_2935_ _0626_ _1833_ VGND VGND VPWR VPWR _0627_ sky130_fd_sc_hd__or2_1
XFILLER_0_17_237 VGND VGND VPWR VPWR sky130_fd_sc_hd__decap_8
X_2866_ _0572_ VGND VGND VPWR VPWR _0573_ sky130_fd_sc_hd__clkbuf_1
XFILLER_0_72_365 VGND VGND VPWR VPWR sky130_fd_sc_hd__decap_4
XFILLER_0_72_354 VGND VGND VPWR VPWR sky130_fd_sc_hd__fill_2
X_4605_ clknet_leaf_68_clk _0320_ net9 VGND VGND VPWR VPWR tree_instances\[9\].u_tree.pipeline_current_node\[0\]\[6\]
+ sky130_fd_sc_hd__dfrtp_1
X_2797_ _2097_ VGND VGND VPWR VPWR _2102_ sky130_fd_sc_hd__clkbuf_1
X_4536_ clknet_leaf_20_clk _0266_ net11 VGND VGND VPWR VPWR tree_instances\[6\].u_tree.pipeline_frame_id\[0\]\[4\]
+ sky130_fd_sc_hd__dfrtp_1
XFILLER_0_4_197 VGND VGND VPWR VPWR sky130_fd_sc_hd__fill_2
XFILLER_0_68_71 VGND VGND VPWR VPWR sky130_fd_sc_hd__decap_3
X_4467_ clknet_leaf_63_clk _0208_ net9 VGND VGND VPWR VPWR tree_instances\[3\].u_tree.ready_for_next
+ sky130_fd_sc_hd__dfstp_1
X_4398_ clknet_leaf_30_clk _0085_ net11 VGND VGND VPWR VPWR tree_instances\[0\].u_tree.prediction_valid
+ sky130_fd_sc_hd__dfrtp_1
X_3418_ tree_instances\[3\].u_tree.pipeline_frame_id\[0\]\[1\] _0673_ _0030_ VGND
+ VGND VPWR VPWR _1007_ sky130_fd_sc_hd__mux2_1
X_3349_ _0966_ _0960_ VGND VGND VPWR VPWR _0967_ sky130_fd_sc_hd__and2_1
XANTENNA__2927__C net1 VGND VGND VPWR VPWR sky130_fd_sc_hd__diode_2
XTAP_TAPCELL_ROW_56_769 VGND VPWR sky130_fd_sc_hd__tapvpwrvgnd_1
XFILLER_0_95_446 VGND VGND VPWR VPWR sky130_fd_sc_hd__fill_2
XANTENNA__4855__RESET_B net10 VGND VGND VPWR VPWR sky130_fd_sc_hd__diode_2
XFILLER_0_67_137 VPWR VGND VPWR VGND sky130_ef_sc_hd__decap_12
XANTENNA__3052__A1 _0714_ VGND VGND VPWR VPWR sky130_fd_sc_hd__diode_2
XTAP_TAPCELL_ROW_11_316 VGND VPWR sky130_fd_sc_hd__tapvpwrvgnd_1
XFILLER_0_90_195 VGND VGND VPWR VPWR sky130_fd_sc_hd__fill_1
XPHY_EDGE_ROW_39_Left_136 VGND VGND VPWR VPWR sky130_fd_sc_hd__decap_3
XANTENNA_clkbuf_leaf_43_clk_A clknet_3_7__leaf_clk VGND VGND VPWR VPWR sky130_fd_sc_hd__diode_2
XANTENNA__4304__A1 _0672_ VGND VGND VPWR VPWR sky130_fd_sc_hd__diode_2
XFILLER_0_64_29 VGND VGND VPWR VPWR sky130_fd_sc_hd__fill_2
XANTENNA_clkbuf_leaf_58_clk_A clknet_3_4__leaf_clk VGND VGND VPWR VPWR sky130_fd_sc_hd__diode_2
XPHY_EDGE_ROW_48_Left_145 VGND VGND VPWR VPWR sky130_fd_sc_hd__decap_3
XFILLER_0_80_39 VGND VGND VPWR VPWR sky130_fd_sc_hd__decap_4
XANTENNA__4596__RESET_B net9 VGND VGND VPWR VPWR sky130_fd_sc_hd__diode_2
XANTENNA__4525__RESET_B net11 VGND VGND VPWR VPWR sky130_fd_sc_hd__diode_2
XTAP_TAPCELL_ROW_27_482 VGND VPWR sky130_fd_sc_hd__tapvpwrvgnd_1
XANTENNA__3030__A _0689_ VGND VGND VPWR VPWR sky130_fd_sc_hd__diode_2
XFILLER_0_89_15 VPWR VGND VPWR VGND sky130_ef_sc_hd__decap_12
X_2720_ _1600_ VGND VGND VPWR VPWR _2036_ sky130_fd_sc_hd__clkbuf_1
XFILLER_0_13_77 VGND VGND VPWR VPWR sky130_fd_sc_hd__fill_2
XFILLER_0_6_418 VGND VGND VPWR VPWR sky130_fd_sc_hd__fill_2
XFILLER_0_27_557 VGND VGND VPWR VPWR sky130_fd_sc_hd__decap_3
XFILLER_0_42_505 VPWR VGND VPWR VGND sky130_ef_sc_hd__decap_12
XFILLER_0_54_354 VGND VGND VPWR VPWR sky130_fd_sc_hd__decap_3
X_2651_ tree_instances\[19\].u_tree.pipeline_current_node\[0\]\[1\] VGND VGND VPWR
+ VPWR _1973_ sky130_fd_sc_hd__clkbuf_1
XFILLER_0_81_173 VGND VGND VPWR VPWR sky130_fd_sc_hd__decap_4
XPHY_EDGE_ROW_57_Left_154 VGND VGND VPWR VPWR sky130_fd_sc_hd__decap_3
X_2582_ tree_instances\[1\].u_tree.pipeline_current_node\[0\]\[1\] VGND VGND VPWR
+ VPWR _1915_ sky130_fd_sc_hd__clkbuf_1
X_4321_ _1543_ VGND VGND VPWR VPWR _0565_ sky130_fd_sc_hd__clkbuf_1
XFILLER_0_22_273 VGND VGND VPWR VPWR sky130_fd_sc_hd__fill_2
X_4252_ _1508_ VGND VGND VPWR VPWR _0531_ sky130_fd_sc_hd__clkbuf_1
X_3203_ _0872_ _0873_ _0874_ VGND VGND VPWR VPWR _0875_ sky130_fd_sc_hd__a21oi_1
XFILLER_0_38_41 VGND VGND VPWR VPWR sky130_fd_sc_hd__decap_8
XFILLER_0_38_52 VPWR VGND VPWR VGND sky130_ef_sc_hd__decap_12
X_4183_ _1472_ VGND VGND VPWR VPWR _0498_ sky130_fd_sc_hd__clkbuf_1
XPHY_EDGE_ROW_66_Left_163 VGND VGND VPWR VPWR sky130_fd_sc_hd__decap_3
X_3134_ _0694_ tree_instances\[3\].u_tree.frame_id_out\[0\] tree_instances\[3\].u_tree.frame_id_out\[3\]
+ _0702_ _0805_ VGND VGND VPWR VPWR _0806_ sky130_fd_sc_hd__a221oi_1
X_3065_ _0661_ tree_instances\[17\].u_tree.frame_id_out\[4\] VGND VGND VPWR VPWR _0737_
+ sky130_fd_sc_hd__nor2_1
XFILLER_0_49_126 VGND VGND VPWR VPWR sky130_fd_sc_hd__decap_4
XFILLER_0_49_148 VGND VGND VPWR VPWR sky130_fd_sc_hd__fill_2
XTAP_TAPCELL_ROW_53_739 VGND VPWR sky130_fd_sc_hd__tapvpwrvgnd_1
XTAP_TAPCELL_ROW_81_1016 VGND VPWR sky130_fd_sc_hd__tapvpwrvgnd_1
XFILLER_0_9_223 VGND VGND VPWR VPWR sky130_fd_sc_hd__fill_1
X_3967_ _1344_ VGND VGND VPWR VPWR _0410_ sky130_fd_sc_hd__clkbuf_1
XANTENNA__3034__B2 _0697_ VGND VGND VPWR VPWR sky130_fd_sc_hd__diode_2
XANTENNA__3034__A1 _0702_ VGND VGND VPWR VPWR sky130_fd_sc_hd__diode_2
XFILLER_0_45_310 VGND VGND VPWR VPWR sky130_fd_sc_hd__fill_2
XPHY_EDGE_ROW_75_Left_172 VGND VGND VPWR VPWR sky130_fd_sc_hd__decap_3
XFILLER_0_70_83 VGND VGND VPWR VPWR sky130_fd_sc_hd__fill_1
XFILLER_0_18_557 VPWR VGND VPWR VGND sky130_ef_sc_hd__decap_12
X_2918_ _0616_ VGND VGND VPWR VPWR _0038_ sky130_fd_sc_hd__inv_2
X_3898_ _1301_ VGND VGND VPWR VPWR _0384_ sky130_fd_sc_hd__clkbuf_1
Xclkbuf_leaf_30_clk clknet_3_6__leaf_clk VGND VGND VPWR VPWR clknet_leaf_30_clk sky130_fd_sc_hd__clkbuf_4
XFILLER_0_45_387 VGND VGND VPWR VPWR sky130_fd_sc_hd__decap_4
X_2849_ _2151_ VGND VGND VPWR VPWR _2152_ sky130_fd_sc_hd__clkbuf_1
XFILLER_0_5_473 VPWR VGND VPWR VGND sky130_ef_sc_hd__decap_12
X_4519_ clknet_leaf_57_clk _0250_ net13 VGND VGND VPWR VPWR tree_instances\[5\].u_tree.ready_for_next
+ sky130_fd_sc_hd__dfstp_1
XPHY_EDGE_ROW_84_Left_181 VGND VGND VPWR VPWR sky130_fd_sc_hd__decap_3
XTAP_TAPCELL_ROW_69_894 VGND VPWR sky130_fd_sc_hd__tapvpwrvgnd_1
XFILLER_0_68_402 VPWR VGND VPWR VGND sky130_ef_sc_hd__decap_12
XANTENNA__4366__SET_B net12 VGND VGND VPWR VPWR sky130_fd_sc_hd__diode_2
XANTENNA__3273__A1 _0675_ VGND VGND VPWR VPWR sky130_fd_sc_hd__diode_2
XFILLER_0_95_276 VGND VGND VPWR VPWR sky130_fd_sc_hd__decap_4
XFILLER_0_95_243 VGND VGND VPWR VPWR sky130_fd_sc_hd__decap_8
XPHY_EDGE_ROW_93_Left_190 VGND VGND VPWR VPWR sky130_fd_sc_hd__decap_3
XFILLER_0_83_449 VPWR VGND VPWR VGND sky130_ef_sc_hd__decap_12
XTAP_TAPCELL_ROW_24_452 VGND VPWR sky130_fd_sc_hd__tapvpwrvgnd_1
XFILLER_0_36_321 VGND VGND VPWR VPWR sky130_fd_sc_hd__decap_4
Xclkbuf_leaf_21_clk clknet_3_3__leaf_clk VGND VGND VPWR VPWR clknet_leaf_21_clk sky130_fd_sc_hd__clkbuf_4
XFILLER_0_24_505 VPWR VGND VPWR VGND sky130_ef_sc_hd__decap_12
XFILLER_0_36_365 VGND VGND VPWR VPWR sky130_fd_sc_hd__decap_8
XFILLER_0_51_379 VGND VGND VPWR VPWR sky130_fd_sc_hd__decap_8
XFILLER_0_75_39 VGND VGND VPWR VPWR sky130_fd_sc_hd__fill_2
XANTENNA__3025__A _0696_ VGND VGND VPWR VPWR sky130_fd_sc_hd__diode_2
XANTENNA__4777__RESET_B net13 VGND VGND VPWR VPWR sky130_fd_sc_hd__diode_2
XANTENNA__4706__RESET_B net9 VGND VGND VPWR VPWR sky130_fd_sc_hd__diode_2
XFILLER_0_86_221 VPWR VGND VPWR VGND sky130_ef_sc_hd__decap_12
X_4870_ clknet_leaf_43_clk _0056_ net10 VGND VGND VPWR VPWR tree_instances\[16\].u_tree.tree_state\[0\]
+ sky130_fd_sc_hd__dfstp_1
X_3821_ tree_instances\[8\].u_tree.pipeline_valid\[0\] tree_instances\[8\].u_tree.tree_state\[0\]
+ VGND VGND VPWR VPWR _1253_ sky130_fd_sc_hd__nand2_1
XTAP_TAPCELL_ROW_50_709 VGND VPWR sky130_fd_sc_hd__tapvpwrvgnd_1
XFILLER_0_6_215 VPWR VGND VPWR VGND sky130_ef_sc_hd__decap_12
XFILLER_0_82_460 VPWR VGND VPWR VGND sky130_ef_sc_hd__decap_12
XFILLER_0_6_259 VPWR VGND VPWR VGND sky130_ef_sc_hd__decap_12
XFILLER_0_15_505 VPWR VGND VPWR VGND sky130_ef_sc_hd__decap_12
X_3752_ tree_instances\[9\].u_tree.pipeline_current_node\[0\]\[8\] _1208_ VGND VGND
+ VPWR VPWR _1218_ sky130_fd_sc_hd__and2_1
XFILLER_0_27_365 VGND VGND VPWR VPWR sky130_fd_sc_hd__decap_8
XFILLER_0_42_313 VGND VGND VPWR VPWR sky130_fd_sc_hd__fill_1
Xclkbuf_leaf_12_clk clknet_3_2__leaf_clk VGND VGND VPWR VPWR clknet_leaf_12_clk sky130_fd_sc_hd__clkbuf_4
X_2703_ _2015_ VGND VGND VPWR VPWR _2022_ sky130_fd_sc_hd__clkbuf_1
X_3683_ _1625_ VGND VGND VPWR VPWR _1177_ sky130_fd_sc_hd__clkbuf_1
XFILLER_0_42_346 VGND VGND VPWR VPWR sky130_fd_sc_hd__decap_6
XFILLER_0_54_195 VGND VGND VPWR VPWR sky130_fd_sc_hd__fill_1
XFILLER_0_2_421 VPWR VGND VPWR VGND sky130_ef_sc_hd__decap_12
X_2634_ _1959_ VGND VGND VPWR VPWR _1960_ sky130_fd_sc_hd__buf_1
XFILLER_0_40_97 VPWR VGND VPWR VGND sky130_ef_sc_hd__decap_12
XFILLER_0_42_357 VGND VGND VPWR VPWR sky130_fd_sc_hd__fill_1
X_2565_ _1901_ _1902_ VGND VGND VPWR VPWR _1903_ sky130_fd_sc_hd__or2_1
XFILLER_0_10_221 VPWR VGND VPWR VGND sky130_ef_sc_hd__decap_12
XFILLER_0_49_51 VGND VGND VPWR VPWR sky130_fd_sc_hd__fill_2
X_4304_ tree_instances\[20\].u_tree.pipeline_frame_id\[0\]\[1\] _0672_ _0026_ VGND
+ VGND VPWR VPWR _1535_ sky130_fd_sc_hd__mux2_1
X_2496_ _1841_ VGND VGND VPWR VPWR _1842_ sky130_fd_sc_hd__clkbuf_1
X_4235_ tree_instances\[18\].u_tree.pipeline_valid\[0\] tree_instances\[18\].u_tree.tree_state\[0\]
+ VGND VGND VPWR VPWR _1499_ sky130_fd_sc_hd__nand2_1
XFILLER_0_4_53 VGND VGND VPWR VPWR sky130_fd_sc_hd__fill_2
X_4166_ tree_instances\[17\].u_tree.pipeline_current_node\[0\]\[7\] _1444_ VGND VGND
+ VPWR VPWR _1464_ sky130_fd_sc_hd__and2_1
XFILLER_0_65_61 VGND VGND VPWR VPWR sky130_fd_sc_hd__decap_6
X_3117_ _0662_ _0784_ _0785_ _0788_ VGND VGND VPWR VPWR _0789_ sky130_fd_sc_hd__a211o_1
XTAP_TAPCELL_ROW_66_864 VGND VPWR sky130_fd_sc_hd__tapvpwrvgnd_1
XANTENNA__4447__RESET_B net10 VGND VGND VPWR VPWR sky130_fd_sc_hd__diode_2
X_4097_ _1411_ VGND VGND VPWR VPWR _0473_ sky130_fd_sc_hd__clkbuf_1
X_3048_ _0713_ _0715_ _0719_ VGND VGND VPWR VPWR _0720_ sky130_fd_sc_hd__or3b_1
XTAP_TAPCELL_ROW_38_588 VGND VPWR sky130_fd_sc_hd__tapvpwrvgnd_1
XFILLER_0_65_449 VPWR VGND VPWR VGND sky130_ef_sc_hd__decap_12
XFILLER_0_37_107 VGND VGND VPWR VPWR sky130_fd_sc_hd__fill_2
XFILLER_0_92_246 VGND VGND VPWR VPWR sky130_fd_sc_hd__decap_6
XFILLER_0_18_321 VPWR VGND VPWR VGND sky130_ef_sc_hd__decap_12
XFILLER_0_18_354 VGND VGND VPWR VPWR sky130_fd_sc_hd__decap_3
XFILLER_0_18_365 VPWR VGND VPWR VGND sky130_ef_sc_hd__decap_12
XTAP_TAPCELL_ROW_21_422 VGND VPWR sky130_fd_sc_hd__tapvpwrvgnd_1
XFILLER_0_73_482 VGND VGND VPWR VPWR sky130_fd_sc_hd__fill_1
XFILLER_0_45_184 VGND VGND VPWR VPWR sky130_fd_sc_hd__fill_1
XFILLER_0_5_281 VGND VGND VPWR VPWR sky130_fd_sc_hd__fill_1
XFILLER_0_60_187 VGND VGND VPWR VPWR sky130_fd_sc_hd__fill_1
XFILLER_0_41_390 VGND VGND VPWR VPWR sky130_fd_sc_hd__fill_2
XTAP_TAPCELL_ROW_29_500 VGND VPWR sky130_fd_sc_hd__tapvpwrvgnd_1
XFILLER_0_88_519 VGND VGND VPWR VPWR sky130_fd_sc_hd__fill_1
XFILLER_0_68_287 VGND VGND VPWR VPWR sky130_fd_sc_hd__decap_4
XFILLER_0_28_129 VGND VGND VPWR VPWR sky130_fd_sc_hd__decap_8
XFILLER_0_64_493 VGND VGND VPWR VPWR sky130_fd_sc_hd__fill_2
XFILLER_0_36_195 VGND VGND VPWR VPWR sky130_fd_sc_hd__fill_1
XFILLER_0_51_110 VGND VGND VPWR VPWR sky130_fd_sc_hd__fill_2
XFILLER_0_51_187 VGND VGND VPWR VPWR sky130_fd_sc_hd__decap_8
XFILLER_0_51_198 VGND VGND VPWR VPWR sky130_fd_sc_hd__decap_3
X_2350_ tree_instances\[13\].u_tree.pipeline_current_node\[0\]\[6\] VGND VGND VPWR
+ VPWR _1713_ sky130_fd_sc_hd__clkbuf_1
XFILLER_0_19_10 VGND VGND VPWR VPWR sky130_fd_sc_hd__fill_1
X_2281_ tree_instances\[8\].u_tree.pipeline_current_node\[0\]\[0\] VGND VGND VPWR
+ VPWR _1652_ sky130_fd_sc_hd__clkbuf_1
XFILLER_0_19_54 VGND VGND VPWR VPWR sky130_fd_sc_hd__fill_2
X_4020_ _1371_ VGND VGND VPWR VPWR _0436_ sky130_fd_sc_hd__clkbuf_1
Xclkbuf_leaf_1_clk clknet_3_0__leaf_clk VGND VGND VPWR VPWR clknet_leaf_1_clk sky130_fd_sc_hd__clkbuf_4
XANTENNA__4540__RESET_B net11 VGND VGND VPWR VPWR sky130_fd_sc_hd__diode_2
XFILLER_0_35_53 VGND VGND VPWR VPWR sky130_fd_sc_hd__decap_3
XTAP_TAPCELL_ROW_63_834 VGND VPWR sky130_fd_sc_hd__tapvpwrvgnd_1
XFILLER_0_59_243 VGND VGND VPWR VPWR sky130_fd_sc_hd__fill_1
XFILLER_0_19_107 VGND VGND VPWR VPWR sky130_fd_sc_hd__fill_1
XTAP_TAPCELL_ROW_35_558 VGND VPWR sky130_fd_sc_hd__tapvpwrvgnd_1
X_4853_ clknet_leaf_33_clk _0534_ net10 VGND VGND VPWR VPWR tree_instances\[19\].u_tree.pipeline_current_node\[0\]\[8\]
+ sky130_fd_sc_hd__dfrtp_1
XFILLER_0_74_257 VPWR VGND VPWR VGND sky130_ef_sc_hd__decap_12
XFILLER_0_47_449 VGND VGND VPWR VPWR sky130_fd_sc_hd__fill_2
XFILLER_0_62_419 VGND VGND VPWR VPWR sky130_fd_sc_hd__fill_1
X_3804_ tree_instances\[10\].u_tree.pipeline_frame_id\[0\]\[3\] _1192_ _0004_ VGND
+ VGND VPWR VPWR _1245_ sky130_fd_sc_hd__mux2_1
X_4784_ clknet_leaf_44_clk _0472_ net10 VGND VGND VPWR VPWR tree_instances\[16\].u_tree.pipeline_frame_id\[0\]\[1\]
+ sky130_fd_sc_hd__dfrtp_1
X_3735_ _1208_ VGND VGND VPWR VPWR _1209_ sky130_fd_sc_hd__dlymetal6s2s_1
XFILLER_0_55_493 VGND VGND VPWR VPWR sky130_fd_sc_hd__decap_8
XFILLER_0_15_379 VPWR VGND VPWR VGND sky130_ef_sc_hd__decap_12
Xclkload61 clknet_leaf_36_clk VGND VGND VPWR VPWR clkload61/X sky130_fd_sc_hd__clkbuf_1
Xclkload50 clknet_leaf_25_clk VGND VGND VPWR VPWR clkload50/Y sky130_fd_sc_hd__clkinvlp_4
X_3666_ _1167_ VGND VGND VPWR VPWR _0286_ sky130_fd_sc_hd__clkbuf_1
X_2617_ _1944_ VGND VGND VPWR VPWR _1945_ sky130_fd_sc_hd__clkbuf_1
X_3597_ tree_instances\[6\].u_tree.pipeline_frame_id\[0\]\[0\] _0665_ _0036_ VGND
+ VGND VPWR VPWR _1123_ sky130_fd_sc_hd__mux2_1
XFILLER_0_62_3 VGND VGND VPWR VPWR sky130_fd_sc_hd__decap_8
XFILLER_0_11_541 VPWR VGND VPWR VGND sky130_ef_sc_hd__decap_12
XFILLER_0_2_251 VGND VGND VPWR VPWR sky130_fd_sc_hd__fill_1
X_2548_ _1666_ tree_instances\[14\].u_tree.pipeline_valid\[0\] VGND VGND VPWR VPWR
+ _1888_ sky130_fd_sc_hd__or2_1
XANTENNA__4699__RESET_B net9 VGND VGND VPWR VPWR sky130_fd_sc_hd__diode_2
XANTENNA__4628__RESET_B net9 VGND VGND VPWR VPWR sky130_fd_sc_hd__diode_2
XFILLER_0_76_82 VGND VGND VPWR VPWR sky130_fd_sc_hd__fill_2
X_2479_ _1575_ tree_instances\[17\].u_tree.pipeline_valid\[0\] VGND VGND VPWR VPWR
+ _1828_ sky130_fd_sc_hd__or2_1
X_4218_ _1490_ VGND VGND VPWR VPWR _0515_ sky130_fd_sc_hd__clkbuf_1
XANTENNA__3476__A1 _0925_ VGND VGND VPWR VPWR sky130_fd_sc_hd__diode_2
X_4149_ _1450_ VGND VGND VPWR VPWR _1451_ sky130_fd_sc_hd__clkbuf_1
XTAP_TAPCELL_ROW_87_1077 VGND VPWR sky130_fd_sc_hd__tapvpwrvgnd_1
XFILLER_0_93_522 VPWR VGND VPWR VGND sky130_ef_sc_hd__decap_12
XFILLER_0_93_500 VGND VGND VPWR VPWR sky130_fd_sc_hd__decap_4
XFILLER_0_80_205 VGND VGND VPWR VPWR sky130_fd_sc_hd__fill_1
XFILLER_0_73_290 VGND VGND VPWR VPWR sky130_fd_sc_hd__fill_2
Xclkload0 clknet_3_1__leaf_clk VGND VGND VPWR VPWR clkload0/X sky130_fd_sc_hd__clkbuf_4
XFILLER_0_33_121 VGND VGND VPWR VPWR sky130_fd_sc_hd__fill_1
XFILLER_0_21_305 VGND VGND VPWR VPWR sky130_fd_sc_hd__decap_4
XFILLER_0_33_165 VGND VGND VPWR VPWR sky130_fd_sc_hd__decap_3
XANTENNA__4369__RESET_B net9 VGND VGND VPWR VPWR sky130_fd_sc_hd__diode_2
XTAP_TAPCELL_ROW_6_272 VGND VPWR sky130_fd_sc_hd__tapvpwrvgnd_1
XFILLER_0_88_305 VGND VGND VPWR VPWR sky130_fd_sc_hd__decap_3
Xload_slew12 net13 VGND VGND VPWR VPWR net12 sky130_fd_sc_hd__buf_12
XFILLER_0_72_29 VPWR VGND VPWR VGND sky130_ef_sc_hd__decap_12
XTAP_TAPCELL_ROW_60_804 VGND VPWR sky130_fd_sc_hd__tapvpwrvgnd_1
XFILLER_0_29_405 VGND VGND VPWR VPWR sky130_fd_sc_hd__decap_3
XFILLER_0_96_393 VPWR VGND VPWR VGND sky130_ef_sc_hd__decap_12
XFILLER_0_84_533 VPWR VGND VPWR VGND sky130_ef_sc_hd__decap_12
XFILLER_0_29_449 VPWR VGND VPWR VGND sky130_ef_sc_hd__decap_12
XTAP_TAPCELL_ROW_32_528 VGND VPWR sky130_fd_sc_hd__tapvpwrvgnd_1
XFILLER_0_56_246 VGND VGND VPWR VPWR sky130_fd_sc_hd__fill_2
XFILLER_0_71_216 VGND VGND VPWR VPWR sky130_fd_sc_hd__decap_4
XFILLER_0_21_11 VGND VGND VPWR VPWR sky130_fd_sc_hd__fill_1
XFILLER_0_21_88 VGND VGND VPWR VPWR sky130_fd_sc_hd__fill_2
X_3520_ _1071_ VGND VGND VPWR VPWR _1072_ sky130_fd_sc_hd__clkbuf_1
XFILLER_0_12_327 VGND VGND VPWR VPWR sky130_fd_sc_hd__decap_4
X_3451_ _1028_ VGND VGND VPWR VPWR _1029_ sky130_fd_sc_hd__dlymetal6s2s_1
XANTENNA__4792__RESET_B net10 VGND VGND VPWR VPWR sky130_fd_sc_hd__diode_2
X_2402_ tree_instances\[5\].u_tree.pipeline_current_node\[0\]\[1\] tree_instances\[5\].u_tree.pipeline_current_node\[0\]\[2\]
+ VGND VGND VPWR VPWR _1759_ sky130_fd_sc_hd__or2_1
X_3382_ tree_instances\[2\].u_tree.frame_id_out\[0\] tree_instances\[2\].u_tree.pipeline_frame_id\[0\]\[0\]
+ _1891_ VGND VGND VPWR VPWR _0988_ sky130_fd_sc_hd__mux2_1
XFILLER_0_20_393 VGND VGND VPWR VPWR sky130_fd_sc_hd__fill_2
X_2333_ tree_instances\[15\].u_tree.tree_state\[2\] _1698_ tree_instances\[15\].u_tree.tree_state\[1\]
+ VGND VGND VPWR VPWR _0055_ sky130_fd_sc_hd__a21o_1
XANTENNA__4721__RESET_B tree_instances\[0\].u_tree.rst_n VGND VGND VPWR VPWR sky130_fd_sc_hd__diode_2
X_2264_ tree_instances\[0\].u_tree.pipeline_current_node\[0\]\[5\] VGND VGND VPWR
+ VPWR _1639_ sky130_fd_sc_hd__clkbuf_1
XFILLER_0_46_41 VGND VGND VPWR VPWR sky130_fd_sc_hd__decap_4
X_4003_ tree_instances\[14\].u_tree.pipeline_current_node\[0\]\[8\] _1353_ VGND VGND
+ VPWR VPWR _1363_ sky130_fd_sc_hd__and2_1
X_2195_ tree_instances\[13\].u_tree.tree_state\[3\] VGND VGND VPWR VPWR _1577_ sky130_fd_sc_hd__buf_2
XFILLER_0_46_85 VGND VGND VPWR VPWR sky130_fd_sc_hd__fill_2
XTAP_TAPCELL_ROW_76_970 VGND VPWR sky130_fd_sc_hd__tapvpwrvgnd_1
XFILLER_0_75_500 VGND VGND VPWR VPWR sky130_fd_sc_hd__decap_4
XFILLER_0_47_213 VGND VGND VPWR VPWR sky130_fd_sc_hd__decap_8
XFILLER_0_87_393 VGND VGND VPWR VPWR sky130_fd_sc_hd__decap_3
XFILLER_0_62_205 VGND VGND VPWR VPWR sky130_fd_sc_hd__decap_3
X_4836_ clknet_leaf_46_clk _0518_ net13 VGND VGND VPWR VPWR tree_instances\[18\].u_tree.frame_id_out\[0\]
+ sky130_fd_sc_hd__dfrtp_1
XFILLER_0_90_536 VGND VGND VPWR VPWR sky130_fd_sc_hd__fill_2
XFILLER_0_15_110 VGND VGND VPWR VPWR sky130_fd_sc_hd__fill_2
XFILLER_0_28_482 VGND VGND VPWR VPWR sky130_fd_sc_hd__decap_4
X_4767_ clknet_leaf_40_clk _0026_ net10 VGND VGND VPWR VPWR tree_instances\[20\].u_tree.tree_state\[2\]
+ sky130_fd_sc_hd__dfrtp_1
XFILLER_0_43_430 VGND VGND VPWR VPWR sky130_fd_sc_hd__decap_4
X_3718_ _1196_ VGND VGND VPWR VPWR _0309_ sky130_fd_sc_hd__clkbuf_1
X_4698_ clknet_leaf_71_clk _0401_ net9 VGND VGND VPWR VPWR tree_instances\[13\].u_tree.pipeline_current_node\[0\]\[2\]
+ sky130_fd_sc_hd__dfrtp_1
XFILLER_0_70_293 VGND VGND VPWR VPWR sky130_fd_sc_hd__decap_6
X_3649_ _1681_ VGND VGND VPWR VPWR _1157_ sky130_fd_sc_hd__clkbuf_1
XANTENNA__4809__RESET_B net13 VGND VGND VPWR VPWR sky130_fd_sc_hd__diode_2
XFILLER_0_11_382 VGND VGND VPWR VPWR sky130_fd_sc_hd__decap_6
XANTENNA__4462__RESET_B net9 VGND VGND VPWR VPWR sky130_fd_sc_hd__diode_2
XTAP_TAPCELL_ROW_3_242 VGND VPWR sky130_fd_sc_hd__tapvpwrvgnd_1
XPHY_EDGE_ROW_11_Left_108 VGND VGND VPWR VPWR sky130_fd_sc_hd__decap_3
XFILLER_0_66_522 VGND VGND VPWR VPWR sky130_fd_sc_hd__decap_8
XFILLER_0_78_393 VPWR VGND VPWR VGND sky130_ef_sc_hd__decap_12
XFILLER_0_66_533 VPWR VGND VPWR VGND sky130_ef_sc_hd__decap_12
XFILLER_0_38_246 VGND VGND VPWR VPWR sky130_fd_sc_hd__decap_6
XFILLER_0_93_352 VGND VGND VPWR VPWR sky130_fd_sc_hd__decap_3
XFILLER_0_66_566 VGND VGND VPWR VPWR sky130_fd_sc_hd__decap_8
XFILLER_0_93_385 VGND VGND VPWR VPWR sky130_fd_sc_hd__fill_2
XFILLER_0_19_493 VGND VGND VPWR VPWR sky130_fd_sc_hd__fill_2
XFILLER_0_53_249 VGND VGND VPWR VPWR sky130_fd_sc_hd__decap_8
XPHY_EDGE_ROW_20_Left_117 VGND VGND VPWR VPWR sky130_fd_sc_hd__decap_3
XFILLER_0_46_290 VGND VGND VPWR VPWR sky130_fd_sc_hd__decap_8
XFILLER_0_21_113 VPWR VGND VPWR VGND sky130_ef_sc_hd__decap_12
XFILLER_0_83_39 VGND VGND VPWR VPWR sky130_fd_sc_hd__decap_8
XFILLER_0_16_44 VGND VGND VPWR VPWR sky130_fd_sc_hd__decap_4
XANTENNA__3033__A _0704_ VGND VGND VPWR VPWR sky130_fd_sc_hd__diode_2
XFILLER_0_16_77 VGND VGND VPWR VPWR sky130_fd_sc_hd__fill_1
XTAP_TAPCELL_ROW_73_940 VGND VPWR sky130_fd_sc_hd__tapvpwrvgnd_1
X_2951_ tree_instances\[1\].u_tree.tree_state\[0\] VGND VGND VPWR VPWR _0637_ sky130_fd_sc_hd__inv_2
XFILLER_0_69_393 VGND VGND VPWR VPWR sky130_fd_sc_hd__fill_1
XTAP_TAPCELL_ROW_17_377 VGND VPWR sky130_fd_sc_hd__tapvpwrvgnd_1
XFILLER_0_84_363 VGND VGND VPWR VPWR sky130_fd_sc_hd__fill_1
XFILLER_0_29_279 VGND VGND VPWR VPWR sky130_fd_sc_hd__fill_1
X_4621_ clknet_leaf_40_clk _0011_ net10 VGND VGND VPWR VPWR tree_instances\[14\].u_tree.tree_state\[1\]
+ sky130_fd_sc_hd__dfrtp_1
X_2882_ _1795_ VGND VGND VPWR VPWR _0589_ sky130_fd_sc_hd__clkbuf_1
XFILLER_0_44_227 VGND VGND VPWR VPWR sky130_fd_sc_hd__fill_2
XFILLER_0_44_238 VPWR VGND VPWR VGND sky130_ef_sc_hd__decap_12
XANTENNA_clkbuf_0_clk_A net15 VGND VGND VPWR VPWR sky130_fd_sc_hd__diode_2
XFILLER_0_25_452 VGND VGND VPWR VPWR sky130_fd_sc_hd__fill_2
XFILLER_0_4_357 VGND VGND VPWR VPWR sky130_fd_sc_hd__decap_4
X_4552_ clknet_leaf_46_clk _0059_ net13 VGND VGND VPWR VPWR tree_instances\[17\].u_tree.tree_state\[3\]
+ sky130_fd_sc_hd__dfrtp_1
XFILLER_0_40_411 VGND VGND VPWR VPWR sky130_fd_sc_hd__decap_8
X_3503_ _1058_ VGND VGND VPWR VPWR _0232_ sky130_fd_sc_hd__clkbuf_1
XFILLER_0_12_124 VPWR VGND VPWR VGND sky130_ef_sc_hd__decap_12
X_4483_ clknet_leaf_63_clk _0223_ net9 VGND VGND VPWR VPWR tree_instances\[4\].u_tree.pipeline_frame_id\[0\]\[4\]
+ sky130_fd_sc_hd__dfrtp_1
X_3434_ tree_instances\[3\].u_tree.frame_id_out\[4\] tree_instances\[3\].u_tree.pipeline_frame_id\[0\]\[4\]
+ tree_instances\[3\].u_tree.tree_state\[3\] VGND VGND VPWR VPWR _1015_ sky130_fd_sc_hd__mux2_1
XANTENNA__3208__A _0660_ VGND VGND VPWR VPWR sky130_fd_sc_hd__diode_2
XFILLER_0_40_488 VGND VGND VPWR VPWR sky130_fd_sc_hd__fill_2
X_3365_ _0978_ _0960_ VGND VGND VPWR VPWR _0979_ sky130_fd_sc_hd__and2_1
X_3296_ _2161_ _0936_ VGND VGND VPWR VPWR _0937_ sky130_fd_sc_hd__and2_1
X_2316_ _1678_ _1679_ _1683_ VGND VGND VPWR VPWR _1684_ sky130_fd_sc_hd__and3_1
XFILLER_0_57_84 VPWR VGND VPWR VGND sky130_ef_sc_hd__decap_12
X_2247_ _1621_ _1622_ VGND VGND VPWR VPWR _1623_ sky130_fd_sc_hd__and2_1
XFILLER_0_79_113 VGND VGND VPWR VPWR sky130_fd_sc_hd__decap_6
XTAP_TAPCELL_ROW_0_201 VGND VPWR sky130_fd_sc_hd__tapvpwrvgnd_1
XTAP_TAPCELL_ROW_0_212 VGND VPWR sky130_fd_sc_hd__tapvpwrvgnd_1
XFILLER_0_25_3 VPWR VGND VPWR VGND sky130_ef_sc_hd__decap_12
X_2178_ tree_instances\[12\].u_tree.pipeline_current_node\[0\]\[1\] VGND VGND VPWR
+ VPWR _1561_ sky130_fd_sc_hd__clkbuf_1
XFILLER_0_73_72 VPWR VGND VPWR VGND sky130_ef_sc_hd__decap_12
XTAP_TAPCELL_ROW_84_1047 VGND VPWR sky130_fd_sc_hd__tapvpwrvgnd_1
XFILLER_0_67_308 VGND VGND VPWR VPWR sky130_fd_sc_hd__fill_2
XFILLER_0_48_533 VGND VGND VPWR VPWR sky130_fd_sc_hd__fill_2
X_4819_ clknet_leaf_21_clk _0024_ net11 VGND VGND VPWR VPWR tree_instances\[1\].u_tree.tree_state\[2\]
+ sky130_fd_sc_hd__dfrtp_1
XFILLER_0_7_184 VGND VGND VPWR VPWR sky130_fd_sc_hd__decap_4
XFILLER_0_7_151 VPWR VGND VPWR VGND sky130_ef_sc_hd__decap_12
XFILLER_0_43_271 VGND VGND VPWR VPWR sky130_fd_sc_hd__fill_1
XTAP_TAPCELL_ROW_95_1154 VGND VPWR sky130_fd_sc_hd__tapvpwrvgnd_1
XFILLER_0_31_422 VGND VGND VPWR VPWR sky130_fd_sc_hd__decap_6
XANTENNA__4643__RESET_B tree_instances\[0\].u_tree.rst_n VGND VGND VPWR VPWR sky130_fd_sc_hd__diode_2
XANTENNA_clkbuf_leaf_2_clk_A clknet_3_0__leaf_clk VGND VGND VPWR VPWR sky130_fd_sc_hd__diode_2
XPHY_EDGE_ROW_19_Right_19 VGND VGND VPWR VPWR sky130_fd_sc_hd__decap_3
XFILLER_0_39_511 VGND VGND VPWR VPWR sky130_fd_sc_hd__fill_1
XFILLER_0_85_149 VPWR VGND VPWR VGND sky130_ef_sc_hd__decap_12
XTAP_TAPCELL_ROW_70_910 VGND VPWR sky130_fd_sc_hd__tapvpwrvgnd_1
XFILLER_0_66_330 VGND VGND VPWR VPWR sky130_fd_sc_hd__fill_2
XFILLER_0_39_522 VGND VGND VPWR VPWR sky130_fd_sc_hd__fill_1
XFILLER_0_66_363 VGND VGND VPWR VPWR sky130_fd_sc_hd__fill_1
XTAP_TAPCELL_ROW_14_347 VGND VPWR sky130_fd_sc_hd__tapvpwrvgnd_1
XFILLER_0_26_238 VPWR VGND VPWR VGND sky130_ef_sc_hd__decap_12
XFILLER_0_54_525 VGND VGND VPWR VPWR sky130_fd_sc_hd__fill_2
Xclkbuf_3_1__f_clk clknet_0_clk VGND VGND VPWR VPWR clknet_3_1__leaf_clk sky130_fd_sc_hd__clkbuf_16
XANTENNA__4384__RESET_B net10 VGND VGND VPWR VPWR sky130_fd_sc_hd__diode_2
XFILLER_0_22_477 VPWR VGND VPWR VGND sky130_ef_sc_hd__decap_12
XPHY_EDGE_ROW_28_Right_28 VGND VGND VPWR VPWR sky130_fd_sc_hd__decap_3
XFILLER_0_94_27 VGND VGND VPWR VPWR sky130_fd_sc_hd__fill_1
X_3150_ _0733_ tree_instances\[12\].u_tree.frame_id_out\[1\] VGND VGND VPWR VPWR _0822_
+ sky130_fd_sc_hd__xnor2_1
X_3081_ _0726_ tree_instances\[19\].u_tree.frame_id_out\[0\] VGND VGND VPWR VPWR _0753_
+ sky130_fd_sc_hd__nor2_1
XPHY_EDGE_ROW_37_Right_37 VGND VGND VPWR VPWR sky130_fd_sc_hd__decap_3
XFILLER_0_89_488 VGND VGND VPWR VPWR sky130_fd_sc_hd__decap_4
XFILLER_0_76_105 VGND VGND VPWR VPWR sky130_fd_sc_hd__fill_2
XFILLER_0_9_405 VPWR VGND VPWR VGND sky130_ef_sc_hd__decap_12
X_3983_ tree_instances\[4\].u_tree.pipeline_valid\[0\] tree_instances\[4\].u_tree.tree_state\[0\]
+ VGND VGND VPWR VPWR _1352_ sky130_fd_sc_hd__nand2_1
XFILLER_0_45_503 VGND VGND VPWR VPWR sky130_fd_sc_hd__fill_1
XFILLER_0_72_322 VGND VGND VPWR VPWR sky130_fd_sc_hd__fill_2
X_2934_ tree_instances\[4\].u_tree.tree_state\[0\] VGND VGND VPWR VPWR _0626_ sky130_fd_sc_hd__inv_2
XFILLER_0_45_536 VGND VGND VPWR VPWR sky130_fd_sc_hd__decap_3
X_2865_ _0571_ VGND VGND VPWR VPWR _0572_ sky130_fd_sc_hd__clkbuf_1
XFILLER_0_84_193 VGND VGND VPWR VPWR sky130_fd_sc_hd__decap_3
X_4604_ clknet_leaf_69_clk _0319_ net9 VGND VGND VPWR VPWR tree_instances\[9\].u_tree.pipeline_current_node\[0\]\[5\]
+ sky130_fd_sc_hd__dfrtp_1
XPHY_EDGE_ROW_46_Right_46 VGND VGND VPWR VPWR sky130_fd_sc_hd__decap_3
X_4535_ clknet_leaf_19_clk _0265_ net11 VGND VGND VPWR VPWR tree_instances\[6\].u_tree.pipeline_frame_id\[0\]\[3\]
+ sky130_fd_sc_hd__dfrtp_1
X_2796_ _2100_ VGND VGND VPWR VPWR _2101_ sky130_fd_sc_hd__clkbuf_1
XFILLER_0_25_271 VGND VGND VPWR VPWR sky130_fd_sc_hd__decap_8
XFILLER_0_13_455 VGND VGND VPWR VPWR sky130_fd_sc_hd__fill_2
X_4466_ clknet_leaf_62_clk _0207_ net9 VGND VGND VPWR VPWR tree_instances\[3\].u_tree.frame_id_out\[4\]
+ sky130_fd_sc_hd__dfrtp_1
X_4397_ clknet_leaf_29_clk _0145_ net13 VGND VGND VPWR VPWR tree_instances\[0\].u_tree.ready_for_next
+ sky130_fd_sc_hd__dfstp_1
XFILLER_0_68_83 VGND VGND VPWR VPWR sky130_fd_sc_hd__fill_1
XFILLER_0_7_97 VGND VGND VPWR VPWR sky130_fd_sc_hd__decap_3
X_3417_ _1006_ VGND VGND VPWR VPWR _0198_ sky130_fd_sc_hd__clkbuf_1
X_3348_ _0965_ VGND VGND VPWR VPWR _0966_ sky130_fd_sc_hd__clkbuf_1
XFILLER_0_0_393 VPWR VGND VPWR VGND sky130_ef_sc_hd__decap_12
X_3279_ _0927_ VGND VGND VPWR VPWR _0139_ sky130_fd_sc_hd__clkbuf_1
XPHY_EDGE_ROW_55_Right_55 VGND VGND VPWR VPWR sky130_fd_sc_hd__decap_3
XFILLER_0_67_149 VPWR VGND VPWR VGND sky130_ef_sc_hd__decap_12
XFILLER_0_48_330 VGND VGND VPWR VPWR sky130_fd_sc_hd__decap_6
XFILLER_0_48_363 VGND VGND VPWR VPWR sky130_fd_sc_hd__fill_1
XANTENNA__4895__RESET_B net12 VGND VGND VPWR VPWR sky130_fd_sc_hd__diode_2
XFILLER_0_90_141 VPWR VGND VPWR VGND sky130_ef_sc_hd__decap_12
XPHY_EDGE_ROW_64_Right_64 VGND VGND VPWR VPWR sky130_fd_sc_hd__decap_3
XFILLER_0_63_333 VGND VGND VPWR VPWR sky130_fd_sc_hd__decap_3
XTAP_TAPCELL_ROW_11_317 VGND VPWR sky130_fd_sc_hd__tapvpwrvgnd_1
XANTENNA__4824__RESET_B net10 VGND VGND VPWR VPWR sky130_fd_sc_hd__diode_2
XFILLER_0_63_377 VGND VGND VPWR VPWR sky130_fd_sc_hd__fill_2
XFILLER_0_23_208 VPWR VGND VPWR VGND sky130_ef_sc_hd__decap_12
XFILLER_0_51_517 VGND VGND VPWR VPWR sky130_fd_sc_hd__decap_6
XFILLER_0_63_399 VGND VGND VPWR VPWR sky130_fd_sc_hd__fill_1
XPHY_EDGE_ROW_73_Right_73 VGND VGND VPWR VPWR sky130_fd_sc_hd__decap_3
XTAP_TAPCELL_ROW_27_483 VGND VPWR sky130_fd_sc_hd__tapvpwrvgnd_1
XPHY_EDGE_ROW_82_Right_82 VGND VGND VPWR VPWR sky130_fd_sc_hd__decap_3
XFILLER_0_54_300 VGND VGND VPWR VPWR sky130_fd_sc_hd__decap_3
XFILLER_0_13_89 VGND VGND VPWR VPWR sky130_fd_sc_hd__fill_2
XANTENNA__4565__RESET_B net9 VGND VGND VPWR VPWR sky130_fd_sc_hd__diode_2
X_2650_ tree_instances\[19\].u_tree.pipeline_current_node\[0\]\[2\] VGND VGND VPWR
+ VPWR _1972_ sky130_fd_sc_hd__clkbuf_1
XFILLER_0_89_27 VPWR VGND VPWR VGND sky130_ef_sc_hd__decap_12
XFILLER_0_42_517 VPWR VGND VPWR VGND sky130_ef_sc_hd__decap_12
X_2581_ _1913_ VGND VGND VPWR VPWR _1914_ sky130_fd_sc_hd__clkbuf_1
XFILLER_0_1_113 VPWR VGND VPWR VGND sky130_ef_sc_hd__decap_12
XFILLER_0_22_230 VPWR VGND VPWR VGND sky130_ef_sc_hd__decap_12
X_4320_ tree_instances\[20\].u_tree.frame_id_out\[4\] tree_instances\[20\].u_tree.pipeline_frame_id\[0\]\[4\]
+ tree_instances\[20\].u_tree.tree_state\[3\] VGND VGND VPWR VPWR _1543_ sky130_fd_sc_hd__mux2_1
X_4251_ _1993_ _1502_ VGND VGND VPWR VPWR _1508_ sky130_fd_sc_hd__and2_1
XFILLER_0_10_458 VGND VGND VPWR VPWR sky130_fd_sc_hd__fill_2
XPHY_EDGE_ROW_91_Right_91 VGND VGND VPWR VPWR sky130_fd_sc_hd__decap_3
X_3202_ _0726_ tree_instances\[5\].u_tree.frame_id_out\[0\] VGND VGND VPWR VPWR _0874_
+ sky130_fd_sc_hd__xor2_1
X_4182_ tree_instances\[17\].u_tree.frame_id_out\[1\] tree_instances\[17\].u_tree.pipeline_frame_id\[0\]\[1\]
+ _1827_ VGND VGND VPWR VPWR _1472_ sky130_fd_sc_hd__mux2_1
XFILLER_0_38_64 VPWR VGND VPWR VGND sky130_ef_sc_hd__decap_12
X_3133_ _0654_ tree_instances\[3\].u_tree.frame_id_out\[2\] VGND VGND VPWR VPWR _0805_
+ sky130_fd_sc_hd__and2b_1
X_3064_ _0660_ tree_instances\[17\].u_tree.frame_id_out\[4\] VGND VGND VPWR VPWR _0736_
+ sky130_fd_sc_hd__and2_1
XANTENNA__3806__A1 _1168_ VGND VGND VPWR VPWR sky130_fd_sc_hd__diode_2
XFILLER_0_54_41 VGND VGND VPWR VPWR sky130_fd_sc_hd__decap_4
XFILLER_0_77_447 VGND VGND VPWR VPWR sky130_fd_sc_hd__fill_1
XFILLER_0_54_85 VGND VGND VPWR VPWR sky130_fd_sc_hd__fill_1
XTAP_TAPCELL_ROW_81_1017 VGND VPWR sky130_fd_sc_hd__tapvpwrvgnd_1
XFILLER_0_77_469 VGND VGND VPWR VPWR sky130_fd_sc_hd__fill_2
X_3966_ tree_instances\[13\].u_tree.pipeline_frame_id\[0\]\[2\] _1165_ _0010_ VGND
+ VGND VPWR VPWR _1344_ sky130_fd_sc_hd__mux2_1
XFILLER_0_18_569 VGND VGND VPWR VPWR sky130_fd_sc_hd__decap_4
X_2917_ _0615_ _1686_ VGND VGND VPWR VPWR _0616_ sky130_fd_sc_hd__or2_1
X_3897_ _2007_ _1294_ VGND VGND VPWR VPWR _1301_ sky130_fd_sc_hd__and2_1
XFILLER_0_92_3 VGND VGND VPWR VPWR sky130_fd_sc_hd__decap_8
XFILLER_0_72_163 VGND VGND VPWR VPWR sky130_fd_sc_hd__decap_6
X_2848_ _2149_ VGND VGND VPWR VPWR _2151_ sky130_fd_sc_hd__clkbuf_1
X_2779_ _2075_ VGND VGND VPWR VPWR _2087_ sky130_fd_sc_hd__clkbuf_1
XFILLER_0_79_60 VPWR VGND VPWR VGND sky130_ef_sc_hd__decap_12
XFILLER_0_5_485 VPWR VGND VPWR VGND sky130_ef_sc_hd__decap_12
XFILLER_0_41_561 VPWR VGND VPWR VGND sky130_ef_sc_hd__decap_12
XTAP_TAPCELL_ROW_92_1124 VGND VPWR sky130_fd_sc_hd__tapvpwrvgnd_1
X_4518_ clknet_leaf_58_clk _0249_ net12 VGND VGND VPWR VPWR tree_instances\[5\].u_tree.frame_id_out\[4\]
+ sky130_fd_sc_hd__dfrtp_1
X_4449_ clknet_leaf_69_clk _0190_ tree_instances\[0\].u_tree.rst_n VGND VGND VPWR
+ VPWR tree_instances\[3\].u_tree.pipeline_current_node\[0\]\[1\] sky130_fd_sc_hd__dfrtp_1
XANTENNA__2300__A _1666_ VGND VGND VPWR VPWR sky130_fd_sc_hd__diode_2
XTAP_TAPCELL_ROW_69_895 VGND VPWR sky130_fd_sc_hd__tapvpwrvgnd_1
XFILLER_0_68_414 VGND VGND VPWR VPWR sky130_fd_sc_hd__decap_6
XANTENNA__3131__A _0650_ VGND VGND VPWR VPWR sky130_fd_sc_hd__diode_2
XFILLER_0_95_288 VGND VGND VPWR VPWR sky130_fd_sc_hd__fill_1
XFILLER_0_76_480 VGND VGND VPWR VPWR sky130_fd_sc_hd__decap_3
XTAP_TAPCELL_ROW_24_453 VGND VPWR sky130_fd_sc_hd__tapvpwrvgnd_1
XANTENNA__2970__A _0650_ VGND VGND VPWR VPWR sky130_fd_sc_hd__diode_2
XFILLER_0_76_491 VPWR VGND VPWR VGND sky130_ef_sc_hd__decap_12
XFILLER_0_36_333 VGND VGND VPWR VPWR sky130_fd_sc_hd__fill_1
XFILLER_0_48_193 VGND VGND VPWR VPWR sky130_fd_sc_hd__decap_3
XFILLER_0_24_517 VPWR VGND VPWR VGND sky130_ef_sc_hd__decap_12
XFILLER_0_36_377 VGND VGND VPWR VPWR sky130_fd_sc_hd__fill_2
XFILLER_0_86_233 VPWR VGND VPWR VGND sky130_ef_sc_hd__decap_12
XFILLER_0_59_447 VGND VGND VPWR VPWR sky130_fd_sc_hd__fill_1
XFILLER_0_86_266 VPWR VGND VPWR VGND sky130_ef_sc_hd__decap_12
XANTENNA__4746__RESET_B net10 VGND VGND VPWR VPWR sky130_fd_sc_hd__diode_2
X_3820_ tree_instances\[7\].u_tree.tree_state\[0\] _1685_ _1252_ tree_instances\[7\].u_tree.pipeline_valid\[0\]
+ VGND VGND VPWR VPWR _0355_ sky130_fd_sc_hd__o22a_1
XFILLER_0_27_311 VGND VGND VPWR VPWR sky130_fd_sc_hd__fill_2
XANTENNA__4213__A1 _0664_ VGND VGND VPWR VPWR sky130_fd_sc_hd__diode_2
X_3751_ _1217_ VGND VGND VPWR VPWR _0321_ sky130_fd_sc_hd__clkbuf_1
X_2702_ _1569_ VGND VGND VPWR VPWR _2021_ sky130_fd_sc_hd__clkbuf_1
XFILLER_0_82_472 VGND VGND VPWR VPWR sky130_fd_sc_hd__decap_4
XFILLER_0_6_227 VPWR VGND VPWR VGND sky130_ef_sc_hd__decap_12
XFILLER_0_15_517 VPWR VGND VPWR VGND sky130_ef_sc_hd__decap_12
XFILLER_0_27_377 VGND VGND VPWR VPWR sky130_fd_sc_hd__decap_6
XFILLER_0_54_141 VGND VGND VPWR VPWR sky130_fd_sc_hd__decap_4
XFILLER_0_54_152 VPWR VGND VPWR VGND sky130_ef_sc_hd__decap_12
XFILLER_0_82_483 VGND VGND VPWR VPWR sky130_fd_sc_hd__fill_1
X_3682_ _1618_ VGND VGND VPWR VPWR _1176_ sky130_fd_sc_hd__clkbuf_1
X_2633_ _1957_ _1958_ VGND VGND VPWR VPWR _1959_ sky130_fd_sc_hd__or2_1
X_2564_ tree_instances\[20\].u_tree.pipeline_current_node\[0\]\[3\] VGND VGND VPWR
+ VPWR _1902_ sky130_fd_sc_hd__buf_1
XFILLER_0_2_433 VGND VGND VPWR VPWR sky130_fd_sc_hd__decap_6
XFILLER_0_23_561 VPWR VGND VPWR VGND sky130_ef_sc_hd__decap_12
XFILLER_0_10_233 VGND VGND VPWR VPWR sky130_fd_sc_hd__decap_6
XFILLER_0_2_477 VPWR VGND VPWR VGND sky130_ef_sc_hd__decap_12
X_4303_ _1534_ VGND VGND VPWR VPWR _0556_ sky130_fd_sc_hd__clkbuf_1
X_2495_ _1838_ _1840_ VGND VGND VPWR VPWR _1841_ sky130_fd_sc_hd__or2_1
X_4234_ _1670_ _1498_ _0644_ tree_instances\[18\].u_tree.ready_for_next VGND VGND
+ VPWR VPWR _0523_ sky130_fd_sc_hd__a22o_1
X_4165_ _1463_ VGND VGND VPWR VPWR _0489_ sky130_fd_sc_hd__clkbuf_1
X_3116_ _0684_ tree_instances\[4\].u_tree.frame_id_out\[1\] _0786_ _0657_ _0787_ VGND
+ VGND VPWR VPWR _0788_ sky130_fd_sc_hd__a221o_1
X_4096_ tree_instances\[16\].u_tree.pipeline_frame_id\[0\]\[2\] _0674_ _0016_ VGND
+ VGND VPWR VPWR _1411_ sky130_fd_sc_hd__mux2_1
X_3047_ _0694_ tree_instances\[14\].u_tree.frame_id_out\[0\] tree_instances\[14\].u_tree.prediction_valid
+ _0716_ _0718_ VGND VGND VPWR VPWR _0719_ sky130_fd_sc_hd__o2111a_1
XTAP_TAPCELL_ROW_66_865 VGND VPWR sky130_fd_sc_hd__tapvpwrvgnd_1
XTAP_TAPCELL_ROW_38_589 VGND VPWR sky130_fd_sc_hd__tapvpwrvgnd_1
XFILLER_0_81_72 VGND VGND VPWR VPWR sky130_fd_sc_hd__decap_6
XANTENNA__4487__RESET_B tree_instances\[0\].u_tree.rst_n VGND VGND VPWR VPWR sky130_fd_sc_hd__diode_2
XANTENNA__4416__RESET_B net11 VGND VGND VPWR VPWR sky130_fd_sc_hd__diode_2
XANTENNA_clkbuf_leaf_42_clk_A clknet_3_7__leaf_clk VGND VGND VPWR VPWR sky130_fd_sc_hd__diode_2
XFILLER_0_18_333 VPWR VGND VPWR VGND sky130_ef_sc_hd__decap_12
XFILLER_0_92_269 VGND VGND VPWR VPWR sky130_fd_sc_hd__fill_1
X_3949_ _1335_ VGND VGND VPWR VPWR _0401_ sky130_fd_sc_hd__clkbuf_1
XFILLER_0_18_377 VPWR VGND VPWR VGND sky130_ef_sc_hd__decap_12
XTAP_TAPCELL_ROW_21_423 VGND VPWR sky130_fd_sc_hd__tapvpwrvgnd_1
XFILLER_0_45_163 VGND VGND VPWR VPWR sky130_fd_sc_hd__fill_1
XFILLER_0_73_494 VGND VGND VPWR VPWR sky130_fd_sc_hd__decap_3
XANTENNA_clkbuf_leaf_57_clk_A clknet_3_4__leaf_clk VGND VGND VPWR VPWR sky130_fd_sc_hd__diode_2
XANTENNA__3126__A _0651_ VGND VGND VPWR VPWR sky130_fd_sc_hd__diode_2
XANTENNA__2965__A _0646_ VGND VGND VPWR VPWR sky130_fd_sc_hd__diode_2
XTAP_TAPCELL_ROW_29_501 VGND VPWR sky130_fd_sc_hd__tapvpwrvgnd_1
XFILLER_0_68_200 VGND VGND VPWR VPWR sky130_fd_sc_hd__fill_2
XFILLER_0_83_225 VGND VGND VPWR VPWR sky130_fd_sc_hd__fill_2
XFILLER_0_68_266 VGND VGND VPWR VPWR sky130_fd_sc_hd__decap_4
XFILLER_0_36_141 VPWR VGND VPWR VGND sky130_ef_sc_hd__decap_12
XFILLER_0_24_369 VPWR VGND VPWR VGND sky130_ef_sc_hd__decap_12
XFILLER_0_86_39 VPWR VGND VPWR VGND sky130_ef_sc_hd__decap_12
XFILLER_0_19_22 VGND VGND VPWR VPWR sky130_fd_sc_hd__fill_2
XFILLER_0_20_553 VPWR VGND VPWR VGND sky130_ef_sc_hd__decap_12
X_2280_ _1650_ VGND VGND VPWR VPWR _1651_ sky130_fd_sc_hd__clkbuf_1
XFILLER_0_19_44 VGND VGND VPWR VPWR sky130_fd_sc_hd__fill_1
XFILLER_0_35_32 VGND VGND VPWR VPWR sky130_fd_sc_hd__fill_2
XANTENNA__4580__RESET_B net12 VGND VGND VPWR VPWR sky130_fd_sc_hd__diode_2
XTAP_TAPCELL_ROW_63_835 VGND VPWR sky130_fd_sc_hd__tapvpwrvgnd_1
X_4852_ clknet_leaf_36_clk _0533_ net10 VGND VGND VPWR VPWR tree_instances\[19\].u_tree.pipeline_current_node\[0\]\[7\]
+ sky130_fd_sc_hd__dfrtp_1
XTAP_TAPCELL_ROW_35_559 VGND VPWR sky130_fd_sc_hd__tapvpwrvgnd_1
XFILLER_0_47_406 VGND VGND VPWR VPWR sky130_fd_sc_hd__decap_4
XFILLER_0_7_503 VGND VGND VPWR VPWR sky130_fd_sc_hd__fill_1
X_3803_ _1244_ VGND VGND VPWR VPWR _0346_ sky130_fd_sc_hd__clkbuf_1
XFILLER_0_74_269 VPWR VGND VPWR VGND sky130_ef_sc_hd__decap_12
XFILLER_0_51_86 VPWR VGND VPWR VGND sky130_ef_sc_hd__decap_12
X_4783_ clknet_leaf_44_clk _0471_ net13 VGND VGND VPWR VPWR tree_instances\[16\].u_tree.pipeline_frame_id\[0\]\[0\]
+ sky130_fd_sc_hd__dfrtp_1
X_3734_ tree_instances\[9\].u_tree.tree_state\[1\] tree_instances\[9\].u_tree.tree_state\[2\]
+ _0610_ VGND VGND VPWR VPWR _1208_ sky130_fd_sc_hd__or3_1
X_3665_ tree_instances\[7\].u_tree.pipeline_frame_id\[0\]\[3\] _0925_ _0038_ VGND
+ VGND VPWR VPWR _1167_ sky130_fd_sc_hd__mux2_1
X_2616_ tree_instances\[19\].u_tree.pipeline_current_node\[0\]\[5\] _1943_ VGND VGND
+ VPWR VPWR _1944_ sky130_fd_sc_hd__or2_1
Xclkload62 clknet_leaf_37_clk VGND VGND VPWR VPWR clkload62/Y sky130_fd_sc_hd__clkinv_4
Xclkload40 clknet_leaf_56_clk VGND VGND VPWR VPWR clkload40/X sky130_fd_sc_hd__clkbuf_1
XFILLER_0_30_306 VGND VGND VPWR VPWR sky130_fd_sc_hd__fill_2
Xclkload51 clknet_leaf_26_clk VGND VGND VPWR VPWR clkload51/Y sky130_fd_sc_hd__inv_6
X_3596_ _1122_ VGND VGND VPWR VPWR _0261_ sky130_fd_sc_hd__clkbuf_1
XFILLER_0_11_553 VGND VGND VPWR VPWR sky130_fd_sc_hd__decap_6
X_2547_ tree_instances\[2\].u_tree.tree_state\[2\] _1880_ _1887_ tree_instances\[2\].u_tree.tree_state\[1\]
+ VGND VGND VPWR VPWR _0068_ sky130_fd_sc_hd__a31o_1
XANTENNA__3173__B2 _0689_ VGND VGND VPWR VPWR sky130_fd_sc_hd__diode_2
X_2478_ tree_instances\[17\].u_tree.tree_state\[3\] VGND VGND VPWR VPWR _1827_ sky130_fd_sc_hd__buf_2
XFILLER_0_55_3 VGND VGND VPWR VPWR sky130_fd_sc_hd__fill_2
X_4217_ tree_instances\[18\].u_tree.pipeline_frame_id\[0\]\[2\] _0674_ _0020_ VGND
+ VGND VPWR VPWR _1490_ sky130_fd_sc_hd__mux2_1
XANTENNA__4668__RESET_B net12 VGND VGND VPWR VPWR sky130_fd_sc_hd__diode_2
X_4148_ _1449_ VGND VGND VPWR VPWR _1450_ sky130_fd_sc_hd__clkbuf_1
XFILLER_0_92_71 VGND VGND VPWR VPWR sky130_fd_sc_hd__fill_2
XFILLER_0_78_531 VGND VGND VPWR VPWR sky130_fd_sc_hd__fill_1
X_4079_ _1402_ VGND VGND VPWR VPWR _0464_ sky130_fd_sc_hd__clkbuf_1
XTAP_TAPCELL_ROW_87_1078 VGND VPWR sky130_fd_sc_hd__tapvpwrvgnd_1
XFILLER_0_78_553 VPWR VGND VPWR VGND sky130_ef_sc_hd__decap_12
XFILLER_0_93_512 VGND VGND VPWR VPWR sky130_fd_sc_hd__decap_4
XFILLER_0_93_534 VPWR VGND VPWR VGND sky130_ef_sc_hd__decap_12
XFILLER_0_18_141 VGND VGND VPWR VPWR sky130_fd_sc_hd__decap_8
XFILLER_0_80_239 VGND VGND VPWR VPWR sky130_fd_sc_hd__decap_3
Xclkload1 clknet_3_3__leaf_clk VGND VGND VPWR VPWR clkload1/Y sky130_fd_sc_hd__inv_2
XFILLER_0_61_486 VPWR VGND VPWR VGND sky130_ef_sc_hd__decap_12
XFILLER_0_33_177 VGND VGND VPWR VPWR sky130_fd_sc_hd__decap_3
XTAP_TAPCELL_ROW_6_273 VGND VPWR sky130_fd_sc_hd__tapvpwrvgnd_1
Xload_slew13 tree_instances\[0\].u_tree.rst_n VGND VGND VPWR VPWR net13 sky130_fd_sc_hd__clkbuf_16
XFILLER_0_88_328 VPWR VGND VPWR VGND sky130_ef_sc_hd__decap_12
XANTENNA__4338__RESET_B net10 VGND VGND VPWR VPWR sky130_fd_sc_hd__diode_2
XFILLER_0_96_361 VGND VGND VPWR VPWR sky130_fd_sc_hd__decap_3
XTAP_TAPCELL_ROW_60_805 VGND VPWR sky130_fd_sc_hd__tapvpwrvgnd_1
XFILLER_0_84_545 VPWR VGND VPWR VGND sky130_ef_sc_hd__decap_12
XFILLER_0_29_439 VGND VGND VPWR VPWR sky130_fd_sc_hd__fill_2
XTAP_TAPCELL_ROW_32_529 VGND VPWR sky130_fd_sc_hd__tapvpwrvgnd_1
XFILLER_0_64_280 VGND VGND VPWR VPWR sky130_fd_sc_hd__fill_2
XFILLER_0_24_133 VGND VGND VPWR VPWR sky130_fd_sc_hd__decap_6
X_3450_ tree_instances\[4\].u_tree.tree_state\[2\] tree_instances\[4\].u_tree.tree_state\[1\]
+ _0627_ VGND VGND VPWR VPWR _1028_ sky130_fd_sc_hd__or3_1
XANTENNA__3155__A1 _0648_ VGND VGND VPWR VPWR sky130_fd_sc_hd__diode_2
X_3381_ _0987_ VGND VGND VPWR VPWR _0181_ sky130_fd_sc_hd__clkbuf_1
X_2401_ tree_instances\[5\].u_tree.pipeline_current_node\[0\]\[4\] VGND VGND VPWR
+ VPWR _1758_ sky130_fd_sc_hd__clkbuf_1
XANTENNA__3155__B2 _0655_ VGND VGND VPWR VPWR sky130_fd_sc_hd__diode_2
X_2332_ _1688_ _1692_ _1697_ VGND VGND VPWR VPWR _1698_ sky130_fd_sc_hd__nor3_1
XFILLER_0_41_9 VGND VGND VPWR VPWR sky130_fd_sc_hd__fill_1
X_2263_ _1635_ _1637_ VGND VGND VPWR VPWR _1638_ sky130_fd_sc_hd__nor2_1
X_4002_ _1362_ VGND VGND VPWR VPWR _0427_ sky130_fd_sc_hd__clkbuf_1
X_2194_ _1575_ tree_instances\[13\].u_tree.pipeline_valid\[0\] VGND VGND VPWR VPWR
+ _1576_ sky130_fd_sc_hd__or2_1
XANTENNA__4761__RESET_B net13 VGND VGND VPWR VPWR sky130_fd_sc_hd__diode_2
XTAP_TAPCELL_ROW_76_971 VGND VPWR sky130_fd_sc_hd__tapvpwrvgnd_1
XFILLER_0_1_55 VGND VGND VPWR VPWR sky130_fd_sc_hd__fill_1
XTAP_TAPCELL_ROW_48_684 VGND VPWR sky130_fd_sc_hd__tapvpwrvgnd_1
XFILLER_0_62_41 VGND VGND VPWR VPWR sky130_fd_sc_hd__decap_4
XFILLER_0_1_77 VGND VGND VPWR VPWR sky130_fd_sc_hd__fill_2
XFILLER_0_62_85 VPWR VGND VPWR VGND sky130_ef_sc_hd__decap_12
XFILLER_0_47_225 VGND VGND VPWR VPWR sky130_fd_sc_hd__decap_3
XFILLER_0_75_567 VGND VGND VPWR VPWR sky130_fd_sc_hd__decap_6
XFILLER_0_35_409 VGND VGND VPWR VPWR sky130_fd_sc_hd__fill_2
X_4835_ clknet_leaf_48_clk _0517_ net10 VGND VGND VPWR VPWR tree_instances\[18\].u_tree.pipeline_frame_id\[0\]\[4\]
+ sky130_fd_sc_hd__dfrtp_1
XFILLER_0_47_258 VGND VGND VPWR VPWR sky130_fd_sc_hd__fill_2
X_4766_ clknet_leaf_40_clk _0025_ net10 VGND VGND VPWR VPWR tree_instances\[20\].u_tree.tree_state\[1\]
+ sky130_fd_sc_hd__dfrtp_1
XFILLER_0_62_239 VGND VGND VPWR VPWR sky130_fd_sc_hd__fill_1
X_3717_ tree_instances\[8\].u_tree.frame_id_out\[1\] tree_instances\[8\].u_tree.pipeline_frame_id\[0\]\[1\]
+ _1668_ VGND VGND VPWR VPWR _1196_ sky130_fd_sc_hd__mux2_1
XFILLER_0_43_453 VGND VGND VPWR VPWR sky130_fd_sc_hd__fill_1
X_4697_ clknet_leaf_71_clk _0400_ net9 VGND VGND VPWR VPWR tree_instances\[13\].u_tree.pipeline_current_node\[0\]\[1\]
+ sky130_fd_sc_hd__dfrtp_1
X_3648_ _1156_ VGND VGND VPWR VPWR _0279_ sky130_fd_sc_hd__clkbuf_1
XFILLER_0_3_561 VPWR VGND VPWR VGND sky130_ef_sc_hd__decap_12
XFILLER_0_30_114 VGND VGND VPWR VPWR sky130_fd_sc_hd__decap_4
X_3579_ _1110_ VGND VGND VPWR VPWR _0256_ sky130_fd_sc_hd__clkbuf_1
XANTENNA__4849__RESET_B net13 VGND VGND VPWR VPWR sky130_fd_sc_hd__diode_2
XANTENNA__4491__SET_B net11 VGND VGND VPWR VPWR sky130_fd_sc_hd__diode_2
XTAP_TAPCELL_ROW_3_243 VGND VPWR sky130_fd_sc_hd__tapvpwrvgnd_1
XANTENNA__4431__RESET_B net13 VGND VGND VPWR VPWR sky130_fd_sc_hd__diode_2
XFILLER_0_93_331 VGND VGND VPWR VPWR sky130_fd_sc_hd__fill_1
XFILLER_0_93_320 VGND VGND VPWR VPWR sky130_fd_sc_hd__fill_2
XFILLER_0_66_545 VGND VGND VPWR VPWR sky130_fd_sc_hd__decap_6
XFILLER_0_93_375 VGND VGND VPWR VPWR sky130_fd_sc_hd__fill_2
XFILLER_0_19_461 VPWR VGND VPWR VGND sky130_ef_sc_hd__decap_12
XFILLER_0_34_442 VGND VGND VPWR VPWR sky130_fd_sc_hd__fill_2
XFILLER_0_34_475 VGND VGND VPWR VPWR sky130_fd_sc_hd__fill_1
XFILLER_0_21_125 VPWR VGND VPWR VGND sky130_ef_sc_hd__decap_12
XFILLER_0_21_169 VPWR VGND VPWR VGND sky130_ef_sc_hd__decap_12
XFILLER_0_76_309 VGND VGND VPWR VPWR sky130_fd_sc_hd__decap_6
XTAP_TAPCELL_ROW_73_941 VGND VPWR sky130_fd_sc_hd__tapvpwrvgnd_1
XFILLER_0_69_361 VGND VGND VPWR VPWR sky130_fd_sc_hd__decap_3
XTAP_TAPCELL_ROW_45_654 VGND VPWR sky130_fd_sc_hd__tapvpwrvgnd_1
X_2950_ _0636_ VGND VGND VPWR VPWR _0012_ sky130_fd_sc_hd__inv_2
XTAP_TAPCELL_ROW_17_378 VGND VPWR sky130_fd_sc_hd__tapvpwrvgnd_1
XFILLER_0_57_567 VGND VGND VPWR VPWR sky130_fd_sc_hd__decap_6
XFILLER_0_32_33 VGND VGND VPWR VPWR sky130_fd_sc_hd__decap_3
X_2881_ _0587_ VGND VGND VPWR VPWR _0588_ sky130_fd_sc_hd__clkbuf_1
X_4620_ clknet_leaf_39_clk _0052_ net10 VGND VGND VPWR VPWR tree_instances\[14\].u_tree.tree_state\[0\]
+ sky130_fd_sc_hd__dfstp_1
XFILLER_0_44_217 VGND VGND VPWR VPWR sky130_fd_sc_hd__decap_3
XFILLER_0_25_442 VGND VGND VPWR VPWR sky130_fd_sc_hd__fill_1
XANTENNA__3376__A1 _0675_ VGND VGND VPWR VPWR sky130_fd_sc_hd__diode_2
XFILLER_0_32_99 VPWR VGND VPWR VGND sky130_ef_sc_hd__decap_12
XFILLER_0_25_486 VGND VGND VPWR VPWR sky130_fd_sc_hd__decap_8
X_4551_ clknet_leaf_47_clk _0018_ net13 VGND VGND VPWR VPWR tree_instances\[17\].u_tree.tree_state\[2\]
+ sky130_fd_sc_hd__dfrtp_1
X_3502_ _1057_ _1054_ VGND VGND VPWR VPWR _1058_ sky130_fd_sc_hd__and2_1
XFILLER_0_12_136 VGND VGND VPWR VPWR sky130_fd_sc_hd__decap_4
X_4482_ clknet_leaf_61_clk _0222_ tree_instances\[0\].u_tree.rst_n VGND VGND VPWR
+ VPWR tree_instances\[4\].u_tree.pipeline_frame_id\[0\]\[3\] sky130_fd_sc_hd__dfrtp_1
X_3433_ _1014_ VGND VGND VPWR VPWR _0206_ sky130_fd_sc_hd__clkbuf_1
X_3364_ _1882_ VGND VGND VPWR VPWR _0978_ sky130_fd_sc_hd__clkbuf_1
X_3295_ _0935_ VGND VGND VPWR VPWR _0936_ sky130_fd_sc_hd__buf_1
X_2315_ _1682_ VGND VGND VPWR VPWR _1683_ sky130_fd_sc_hd__clkbuf_1
XFILLER_0_57_96 VPWR VGND VPWR VGND sky130_ef_sc_hd__decap_12
X_2246_ tree_instances\[17\].u_tree.pipeline_current_node\[0\]\[7\] tree_instances\[17\].u_tree.pipeline_current_node\[0\]\[8\]
+ VGND VGND VPWR VPWR _1622_ sky130_fd_sc_hd__nor2_1
XTAP_TAPCELL_ROW_0_202 VGND VPWR sky130_fd_sc_hd__tapvpwrvgnd_1
X_2177_ _1559_ VGND VGND VPWR VPWR _1560_ sky130_fd_sc_hd__clkbuf_1
XFILLER_0_73_51 VGND VGND VPWR VPWR sky130_fd_sc_hd__decap_4
XTAP_TAPCELL_ROW_0_213 VGND VPWR sky130_fd_sc_hd__tapvpwrvgnd_1
XFILLER_0_18_3 VGND VGND VPWR VPWR sky130_fd_sc_hd__decap_4
XTAP_TAPCELL_ROW_84_1048 VGND VPWR sky130_fd_sc_hd__tapvpwrvgnd_1
XFILLER_0_79_169 VPWR VGND VPWR VGND sky130_ef_sc_hd__decap_12
XFILLER_0_94_128 VGND VGND VPWR VPWR sky130_fd_sc_hd__decap_8
XFILLER_0_75_331 VGND VGND VPWR VPWR sky130_fd_sc_hd__decap_3
XFILLER_0_48_545 VGND VGND VPWR VPWR sky130_fd_sc_hd__fill_1
XFILLER_0_75_397 VGND VGND VPWR VPWR sky130_fd_sc_hd__fill_1
X_4818_ clknet_leaf_31_clk _0023_ net11 VGND VGND VPWR VPWR tree_instances\[1\].u_tree.tree_state\[1\]
+ sky130_fd_sc_hd__dfrtp_1
XFILLER_0_7_163 VGND VGND VPWR VPWR sky130_fd_sc_hd__decap_4
X_4749_ clknet_leaf_50_clk _0446_ net10 VGND VGND VPWR VPWR tree_instances\[15\].u_tree.pipeline_current_node\[0\]\[5\]
+ sky130_fd_sc_hd__dfrtp_1
XTAP_TAPCELL_ROW_95_1155 VGND VPWR sky130_fd_sc_hd__tapvpwrvgnd_1
XANTENNA__3119__A1 _0655_ VGND VGND VPWR VPWR sky130_fd_sc_hd__diode_2
XANTENNA__4683__RESET_B net12 VGND VGND VPWR VPWR sky130_fd_sc_hd__diode_2
XANTENNA__4612__RESET_B tree_instances\[0\].u_tree.rst_n VGND VGND VPWR VPWR sky130_fd_sc_hd__diode_2
XFILLER_0_58_309 VGND VGND VPWR VPWR sky130_fd_sc_hd__decap_4
XTAP_TAPCELL_ROW_70_911 VGND VPWR sky130_fd_sc_hd__tapvpwrvgnd_1
XTAP_TAPCELL_ROW_42_624 VGND VPWR sky130_fd_sc_hd__tapvpwrvgnd_1
XFILLER_0_93_161 VGND VGND VPWR VPWR sky130_fd_sc_hd__fill_2
XFILLER_0_81_323 VGND VGND VPWR VPWR sky130_fd_sc_hd__fill_1
XTAP_TAPCELL_ROW_14_348 VGND VPWR sky130_fd_sc_hd__tapvpwrvgnd_1
XFILLER_0_26_217 VGND VGND VPWR VPWR sky130_fd_sc_hd__decap_6
XFILLER_0_78_29 VGND VGND VPWR VPWR sky130_fd_sc_hd__decap_8
XFILLER_0_22_456 VGND VGND VPWR VPWR sky130_fd_sc_hd__decap_8
XFILLER_0_94_39 VGND VGND VPWR VPWR sky130_fd_sc_hd__fill_1
XANTENNA__4353__RESET_B net11 VGND VGND VPWR VPWR sky130_fd_sc_hd__diode_2
XANTENNA__3044__A _0661_ VGND VGND VPWR VPWR sky130_fd_sc_hd__diode_2
X_3080_ _0726_ tree_instances\[19\].u_tree.frame_id_out\[0\] VGND VGND VPWR VPWR _0752_
+ sky130_fd_sc_hd__and2_1
XFILLER_0_27_55 VGND VGND VPWR VPWR sky130_fd_sc_hd__fill_1
XFILLER_0_27_99 VPWR VGND VPWR VGND sky130_ef_sc_hd__decap_12
XTAP_TAPCELL_ROW_58_790 VGND VPWR sky130_fd_sc_hd__tapvpwrvgnd_1
XFILLER_0_9_417 VPWR VGND VPWR VGND sky130_ef_sc_hd__decap_12
X_3982_ _1577_ _1027_ _0602_ tree_instances\[13\].u_tree.ready_for_next VGND VGND
+ VPWR VPWR _0418_ sky130_fd_sc_hd__a22o_1
XFILLER_0_43_54 VGND VGND VPWR VPWR sky130_fd_sc_hd__fill_2
XANTENNA__3597__A1 _0665_ VGND VGND VPWR VPWR sky130_fd_sc_hd__diode_2
X_2933_ _1763_ _0625_ tree_instances\[5\].u_tree.tree_state\[2\] VGND VGND VPWR VPWR
+ _0033_ sky130_fd_sc_hd__o21a_1
XFILLER_0_84_161 VPWR VGND VPWR VGND sky130_ef_sc_hd__decap_12
XFILLER_0_17_206 VPWR VGND VPWR VGND sky130_ef_sc_hd__decap_12
X_2864_ _2159_ VGND VGND VPWR VPWR _0571_ sky130_fd_sc_hd__clkbuf_1
XFILLER_0_45_559 VGND VGND VPWR VPWR sky130_fd_sc_hd__fill_1
X_4603_ clknet_leaf_69_clk _0318_ net9 VGND VGND VPWR VPWR tree_instances\[9\].u_tree.pipeline_current_node\[0\]\[4\]
+ sky130_fd_sc_hd__dfrtp_1
X_2795_ _2099_ VGND VGND VPWR VPWR _2100_ sky130_fd_sc_hd__clkbuf_1
XFILLER_0_25_250 VGND VGND VPWR VPWR sky130_fd_sc_hd__decap_8
XFILLER_0_32_209 VGND VGND VPWR VPWR sky130_fd_sc_hd__decap_3
X_4534_ clknet_leaf_20_clk _0264_ net11 VGND VGND VPWR VPWR tree_instances\[6\].u_tree.pipeline_frame_id\[0\]\[2\]
+ sky130_fd_sc_hd__dfrtp_1
XFILLER_0_40_253 VGND VGND VPWR VPWR sky130_fd_sc_hd__fill_1
X_4465_ clknet_leaf_62_clk _0206_ tree_instances\[0\].u_tree.rst_n VGND VGND VPWR
+ VPWR tree_instances\[3\].u_tree.frame_id_out\[3\] sky130_fd_sc_hd__dfrtp_1
X_4396_ clknet_leaf_32_clk _0144_ net13 VGND VGND VPWR VPWR tree_instances\[0\].u_tree.frame_id_out\[4\]
+ sky130_fd_sc_hd__dfrtp_1
XFILLER_0_0_361 VGND VGND VPWR VPWR sky130_fd_sc_hd__decap_3
X_3416_ tree_instances\[3\].u_tree.pipeline_frame_id\[0\]\[0\] _0665_ _0030_ VGND
+ VGND VPWR VPWR _1006_ sky130_fd_sc_hd__mux2_1
X_3347_ _1877_ VGND VGND VPWR VPWR _0965_ sky130_fd_sc_hd__clkbuf_1
X_3278_ tree_instances\[0\].u_tree.pipeline_frame_id\[0\]\[4\] _0682_ _0002_ VGND
+ VGND VPWR VPWR _0927_ sky130_fd_sc_hd__mux2_1
XFILLER_0_84_83 VGND VGND VPWR VPWR sky130_fd_sc_hd__fill_1
X_2229_ _1605_ VGND VGND VPWR VPWR _1606_ sky130_fd_sc_hd__clkbuf_1
XFILLER_0_95_415 VGND VGND VPWR VPWR sky130_fd_sc_hd__fill_2
XFILLER_0_48_342 VGND VGND VPWR VPWR sky130_fd_sc_hd__decap_4
XFILLER_0_48_375 VGND VGND VPWR VPWR sky130_fd_sc_hd__fill_2
XFILLER_0_63_345 VGND VGND VPWR VPWR sky130_fd_sc_hd__fill_1
XTAP_TAPCELL_ROW_11_318 VGND VPWR sky130_fd_sc_hd__tapvpwrvgnd_1
XFILLER_0_90_153 VPWR VGND VPWR VGND sky130_ef_sc_hd__decap_12
XFILLER_0_63_367 VGND VGND VPWR VPWR sky130_fd_sc_hd__decap_4
XFILLER_0_90_197 VGND VGND VPWR VPWR sky130_fd_sc_hd__fill_2
XFILLER_0_31_231 VGND VGND VPWR VPWR sky130_fd_sc_hd__fill_2
XANTENNA__3760__A1 _1192_ VGND VGND VPWR VPWR sky130_fd_sc_hd__diode_2
XFILLER_0_7_3 VPWR VGND VPWR VGND sky130_ef_sc_hd__decap_12
XANTENNA_load_slew12_A net13 VGND VGND VPWR VPWR sky130_fd_sc_hd__diode_2
XFILLER_0_58_139 VGND VGND VPWR VPWR sky130_fd_sc_hd__fill_1
XTAP_TAPCELL_ROW_55_760 VGND VPWR sky130_fd_sc_hd__tapvpwrvgnd_1
XFILLER_0_13_24 VGND VGND VPWR VPWR sky130_fd_sc_hd__fill_1
XFILLER_0_66_150 VPWR VGND VPWR VGND sky130_ef_sc_hd__decap_12
XFILLER_0_42_529 VGND VGND VPWR VPWR sky130_fd_sc_hd__decap_3
XFILLER_0_81_197 VGND VGND VPWR VPWR sky130_fd_sc_hd__fill_2
X_2580_ _1911_ _1912_ VGND VGND VPWR VPWR _1913_ sky130_fd_sc_hd__or2_1
XFILLER_0_1_125 VGND VGND VPWR VPWR sky130_fd_sc_hd__decap_3
XFILLER_0_1_103 VGND VGND VPWR VPWR sky130_fd_sc_hd__decap_8
XFILLER_0_22_242 VGND VGND VPWR VPWR sky130_fd_sc_hd__decap_6
XANTENNA__4534__RESET_B net11 VGND VGND VPWR VPWR sky130_fd_sc_hd__diode_2
X_4250_ _1507_ VGND VGND VPWR VPWR _0530_ sky130_fd_sc_hd__clkbuf_1
XFILLER_0_1_169 VPWR VGND VPWR VGND sky130_ef_sc_hd__decap_12
X_3201_ _0653_ tree_instances\[5\].u_tree.frame_id_out\[2\] VGND VGND VPWR VPWR _0873_
+ sky130_fd_sc_hd__or2_1
X_4181_ _1471_ VGND VGND VPWR VPWR _0497_ sky130_fd_sc_hd__clkbuf_1
X_3132_ _0647_ tree_instances\[3\].u_tree.frame_id_out\[0\] _0802_ _0661_ _0803_ VGND
+ VGND VPWR VPWR _0804_ sky130_fd_sc_hd__o221a_1
XFILLER_0_38_76 VGND VGND VPWR VPWR sky130_fd_sc_hd__decap_4
X_3063_ _0733_ _0730_ tree_instances\[17\].u_tree.frame_id_out\[3\] _0690_ _0734_
+ VGND VGND VPWR VPWR _0735_ sky130_fd_sc_hd__o221a_1
XTAP_TAPCELL_ROW_81_1018 VGND VPWR sky130_fd_sc_hd__tapvpwrvgnd_1
XFILLER_0_9_225 VGND VGND VPWR VPWR sky130_fd_sc_hd__decap_6
XFILLER_0_9_203 VGND VGND VPWR VPWR sky130_fd_sc_hd__decap_3
XFILLER_0_92_418 VGND VGND VPWR VPWR sky130_fd_sc_hd__fill_2
XFILLER_0_70_41 VPWR VGND VPWR VGND sky130_ef_sc_hd__decap_12
X_3965_ _1343_ VGND VGND VPWR VPWR _0409_ sky130_fd_sc_hd__clkbuf_1
X_3896_ _1300_ VGND VGND VPWR VPWR _0383_ sky130_fd_sc_hd__clkbuf_1
XFILLER_0_70_85 VPWR VGND VPWR VGND sky130_ef_sc_hd__decap_12
XFILLER_0_9_269 VGND VGND VPWR VPWR sky130_fd_sc_hd__fill_1
X_2916_ tree_instances\[7\].u_tree.tree_state\[0\] VGND VGND VPWR VPWR _0615_ sky130_fd_sc_hd__inv_2
X_2847_ _2142_ VGND VGND VPWR VPWR _2150_ sky130_fd_sc_hd__clkbuf_1
XFILLER_0_5_420 VPWR VGND VPWR VGND sky130_ef_sc_hd__decap_12
XFILLER_0_85_3 VGND VGND VPWR VPWR sky130_fd_sc_hd__decap_8
XFILLER_0_72_197 VGND VGND VPWR VPWR sky130_fd_sc_hd__decap_8
XFILLER_0_79_72 VPWR VGND VPWR VGND sky130_ef_sc_hd__decap_12
X_2778_ _2081_ VGND VGND VPWR VPWR _2086_ sky130_fd_sc_hd__clkbuf_1
XFILLER_0_5_497 VGND VGND VPWR VPWR sky130_fd_sc_hd__decap_6
XFILLER_0_41_540 VPWR VGND VPWR VGND sky130_ef_sc_hd__decap_12
XTAP_TAPCELL_ROW_92_1125 VGND VPWR sky130_fd_sc_hd__tapvpwrvgnd_1
X_4517_ clknet_leaf_63_clk _0248_ tree_instances\[0\].u_tree.rst_n VGND VGND VPWR
+ VPWR tree_instances\[5\].u_tree.frame_id_out\[3\] sky130_fd_sc_hd__dfrtp_1
XANTENNA_clkbuf_leaf_1_clk_A clknet_3_0__leaf_clk VGND VGND VPWR VPWR sky130_fd_sc_hd__diode_2
XFILLER_0_41_573 VGND VGND VPWR VPWR sky130_fd_sc_hd__fill_1
X_4448_ clknet_leaf_69_clk _0189_ tree_instances\[0\].u_tree.rst_n VGND VGND VPWR
+ VPWR tree_instances\[3\].u_tree.pipeline_current_node\[0\]\[0\] sky130_fd_sc_hd__dfrtp_1
X_4379_ clknet_leaf_36_clk _0127_ net10 VGND VGND VPWR VPWR tree_instances\[0\].u_tree.pipeline_current_node\[0\]\[1\]
+ sky130_fd_sc_hd__dfrtp_1
XTAP_TAPCELL_ROW_69_896 VGND VPWR sky130_fd_sc_hd__tapvpwrvgnd_1
XANTENNA__4620__SET_B net10 VGND VGND VPWR VPWR sky130_fd_sc_hd__diode_2
XFILLER_0_95_223 VGND VGND VPWR VPWR sky130_fd_sc_hd__fill_1
XFILLER_0_68_448 VPWR VGND VPWR VGND sky130_ef_sc_hd__decap_12
XTAP_TAPCELL_ROW_52_730 VGND VPWR sky130_fd_sc_hd__tapvpwrvgnd_1
XFILLER_0_91_440 VGND VGND VPWR VPWR sky130_fd_sc_hd__fill_1
XFILLER_0_24_529 VGND VGND VPWR VPWR sky130_fd_sc_hd__decap_3
XFILLER_0_51_337 VGND VGND VPWR VPWR sky130_fd_sc_hd__fill_2
XFILLER_0_32_573 VGND VGND VPWR VPWR sky130_fd_sc_hd__fill_1
XFILLER_0_86_245 VGND VGND VPWR VPWR sky130_fd_sc_hd__fill_1
XFILLER_0_24_67 VGND VGND VPWR VPWR sky130_fd_sc_hd__fill_2
XFILLER_0_86_278 VPWR VGND VPWR VGND sky130_ef_sc_hd__decap_12
X_3750_ _1587_ _1208_ VGND VGND VPWR VPWR _1217_ sky130_fd_sc_hd__and2_1
X_2701_ _1561_ VGND VGND VPWR VPWR _2020_ sky130_fd_sc_hd__clkbuf_1
XANTENNA__4786__RESET_B net13 VGND VGND VPWR VPWR sky130_fd_sc_hd__diode_2
XFILLER_0_6_239 VGND VGND VPWR VPWR sky130_fd_sc_hd__decap_4
XFILLER_0_40_33 VPWR VGND VPWR VGND sky130_ef_sc_hd__decap_12
XFILLER_0_42_304 VGND VGND VPWR VPWR sky130_fd_sc_hd__decap_4
XFILLER_0_54_164 VGND VGND VPWR VPWR sky130_fd_sc_hd__decap_8
XFILLER_0_82_495 VGND VGND VPWR VPWR sky130_fd_sc_hd__decap_4
X_3681_ _1624_ VGND VGND VPWR VPWR _1175_ sky130_fd_sc_hd__clkbuf_1
XFILLER_0_15_529 VPWR VGND VPWR VGND sky130_ef_sc_hd__decap_12
XFILLER_0_54_197 VPWR VGND VPWR VGND sky130_ef_sc_hd__decap_12
X_2632_ tree_instances\[18\].u_tree.pipeline_current_node\[0\]\[3\] tree_instances\[18\].u_tree.pipeline_current_node\[0\]\[2\]
+ VGND VGND VPWR VPWR _1958_ sky130_fd_sc_hd__or2_1
X_2563_ tree_instances\[20\].u_tree.pipeline_current_node\[0\]\[2\] VGND VGND VPWR
+ VPWR _1901_ sky130_fd_sc_hd__clkbuf_1
XFILLER_0_23_573 VGND VGND VPWR VPWR sky130_fd_sc_hd__fill_1
XFILLER_0_2_489 VPWR VGND VPWR VGND sky130_ef_sc_hd__decap_12
X_4302_ tree_instances\[20\].u_tree.pipeline_frame_id\[0\]\[0\] _0664_ _0026_ VGND
+ VGND VPWR VPWR _1534_ sky130_fd_sc_hd__mux2_1
X_2494_ _1839_ VGND VGND VPWR VPWR _1840_ sky130_fd_sc_hd__clkbuf_1
X_4233_ tree_instances\[18\].u_tree.tree_state\[0\] _1669_ VGND VGND VPWR VPWR _1498_
+ sky130_fd_sc_hd__nand2_1
XFILLER_0_49_97 VGND VGND VPWR VPWR sky130_fd_sc_hd__fill_2
XFILLER_0_65_30 VPWR VGND VPWR VGND sky130_ef_sc_hd__decap_12
X_4164_ _1462_ _1444_ VGND VGND VPWR VPWR _1463_ sky130_fd_sc_hd__and2_1
XFILLER_0_4_77 VGND VGND VPWR VPWR sky130_fd_sc_hd__decap_3
X_3115_ current_voting_frame\[0\] tree_instances\[4\].u_tree.frame_id_out\[0\] VGND
+ VGND VPWR VPWR _0787_ sky130_fd_sc_hd__xor2_1
X_4095_ _1410_ VGND VGND VPWR VPWR _0472_ sky130_fd_sc_hd__clkbuf_1
X_3046_ _0704_ tree_instances\[14\].u_tree.frame_id_out\[2\] tree_instances\[14\].u_tree.frame_id_out\[3\]
+ _0690_ _0717_ VGND VGND VPWR VPWR _0718_ sky130_fd_sc_hd__o221a_1
XFILLER_0_77_223 VGND VGND VPWR VPWR sky130_fd_sc_hd__fill_1
XTAP_TAPCELL_ROW_66_866 VGND VPWR sky130_fd_sc_hd__tapvpwrvgnd_1
XFILLER_0_18_301 VGND VGND VPWR VPWR sky130_fd_sc_hd__decap_6
X_3948_ _1719_ _1332_ VGND VGND VPWR VPWR _1335_ sky130_fd_sc_hd__and2_1
XFILLER_0_33_304 VGND VGND VPWR VPWR sky130_fd_sc_hd__fill_2
X_3879_ _1277_ VGND VGND VPWR VPWR _1289_ sky130_fd_sc_hd__clkbuf_1
XANTENNA__4456__RESET_B net9 VGND VGND VPWR VPWR sky130_fd_sc_hd__diode_2
XFILLER_0_18_389 VGND VGND VPWR VPWR sky130_fd_sc_hd__decap_8
XFILLER_0_33_326 VGND VGND VPWR VPWR sky130_fd_sc_hd__fill_2
XFILLER_0_33_337 VGND VGND VPWR VPWR sky130_fd_sc_hd__fill_2
XFILLER_0_60_145 VGND VGND VPWR VPWR sky130_fd_sc_hd__decap_6
XFILLER_0_14_573 VGND VGND VPWR VPWR sky130_fd_sc_hd__fill_1
XTAP_TAPCELL_ROW_29_502 VGND VPWR sky130_fd_sc_hd__tapvpwrvgnd_1
XANTENNA__3142__A _0660_ VGND VGND VPWR VPWR sky130_fd_sc_hd__diode_2
XFILLER_0_49_470 VPWR VGND VPWR VGND sky130_ef_sc_hd__decap_12
XFILLER_0_56_407 VPWR VGND VPWR VGND sky130_ef_sc_hd__decap_12
XFILLER_0_56_429 VGND VGND VPWR VPWR sky130_fd_sc_hd__fill_2
XFILLER_0_36_153 VGND VGND VPWR VPWR sky130_fd_sc_hd__decap_3
XFILLER_0_91_281 VPWR VGND VPWR VGND sky130_ef_sc_hd__decap_12
XANTENNA__3706__A1 _1124_ VGND VGND VPWR VPWR sky130_fd_sc_hd__diode_2
XFILLER_0_51_167 VGND VGND VPWR VPWR sky130_fd_sc_hd__fill_1
XFILLER_0_86_29 VGND VGND VPWR VPWR sky130_fd_sc_hd__fill_2
XFILLER_0_20_565 VGND VGND VPWR VPWR sky130_fd_sc_hd__decap_8
XFILLER_0_87_521 VGND VGND VPWR VPWR sky130_fd_sc_hd__fill_2
XFILLER_0_35_44 VGND VGND VPWR VPWR sky130_fd_sc_hd__fill_1
XTAP_TAPCELL_ROW_63_836 VGND VPWR sky130_fd_sc_hd__tapvpwrvgnd_1
XFILLER_0_59_256 VPWR VGND VPWR VGND sky130_ef_sc_hd__decap_12
X_4851_ clknet_leaf_32_clk _0532_ net13 VGND VGND VPWR VPWR tree_instances\[19\].u_tree.pipeline_current_node\[0\]\[6\]
+ sky130_fd_sc_hd__dfrtp_1
XFILLER_0_59_289 VGND VGND VPWR VPWR sky130_fd_sc_hd__decap_4
XFILLER_0_74_226 VPWR VGND VPWR VGND sky130_ef_sc_hd__decap_12
X_3802_ tree_instances\[10\].u_tree.pipeline_frame_id\[0\]\[2\] _1165_ _0004_ VGND
+ VGND VPWR VPWR _1244_ sky130_fd_sc_hd__mux2_1
XFILLER_0_27_142 VGND VGND VPWR VPWR sky130_fd_sc_hd__fill_2
X_4782_ clknet_leaf_51_clk _0470_ net13 VGND VGND VPWR VPWR tree_instances\[16\].u_tree.pipeline_current_node\[0\]\[8\]
+ sky130_fd_sc_hd__dfrtp_1
XFILLER_0_55_462 VGND VGND VPWR VPWR sky130_fd_sc_hd__decap_3
XFILLER_0_70_421 VGND VGND VPWR VPWR sky130_fd_sc_hd__fill_2
X_3733_ _1205_ VGND VGND VPWR VPWR _1207_ sky130_fd_sc_hd__clkbuf_1
XFILLER_0_7_559 VGND VGND VPWR VPWR sky130_fd_sc_hd__fill_1
XFILLER_0_51_98 VGND VGND VPWR VPWR sky130_fd_sc_hd__decap_8
X_3664_ _1166_ VGND VGND VPWR VPWR _0285_ sky130_fd_sc_hd__clkbuf_1
XFILLER_0_42_134 VGND VGND VPWR VPWR sky130_fd_sc_hd__fill_2
X_2615_ tree_instances\[19\].u_tree.pipeline_current_node\[0\]\[4\] VGND VGND VPWR
+ VPWR _1943_ sky130_fd_sc_hd__clkbuf_1
XFILLER_0_70_465 VGND VGND VPWR VPWR sky130_fd_sc_hd__decap_4
Xclkload52 clknet_leaf_27_clk VGND VGND VPWR VPWR clkload52/Y sky130_fd_sc_hd__clkinv_4
Xclkload41 clknet_leaf_58_clk VGND VGND VPWR VPWR clkload41/X sky130_fd_sc_hd__clkbuf_1
Xclkload30 clknet_leaf_7_clk VGND VGND VPWR VPWR clkload30/Y sky130_fd_sc_hd__clkinv_4
X_3595_ tree_instances\[6\].u_tree.pipeline_current_node\[0\]\[8\] _1095_ VGND VGND
+ VPWR VPWR _1122_ sky130_fd_sc_hd__and2_1
Xclkload63 clknet_leaf_38_clk VGND VGND VPWR VPWR clkload63/Y sky130_fd_sc_hd__clkinv_4
XFILLER_0_2_253 VGND VGND VPWR VPWR sky130_fd_sc_hd__decap_8
X_2546_ _1883_ _1884_ _1886_ VGND VGND VPWR VPWR _1887_ sky130_fd_sc_hd__and3b_1
XFILLER_0_2_297 VGND VGND VPWR VPWR sky130_fd_sc_hd__decap_8
X_2477_ _1826_ VGND VGND VPWR VPWR _0001_ sky130_fd_sc_hd__clkbuf_1
X_4216_ _1489_ VGND VGND VPWR VPWR _0514_ sky130_fd_sc_hd__clkbuf_1
XFILLER_0_48_3 VGND VGND VPWR VPWR sky130_fd_sc_hd__fill_1
X_4147_ _1175_ VGND VGND VPWR VPWR _1449_ sky130_fd_sc_hd__clkbuf_1
X_4078_ _2063_ _1399_ VGND VGND VPWR VPWR _1402_ sky130_fd_sc_hd__and2_1
XTAP_TAPCELL_ROW_87_1079 VGND VPWR sky130_fd_sc_hd__tapvpwrvgnd_1
X_3029_ tree_instances\[7\].u_tree.prediction_valid VGND VGND VPWR VPWR _0701_ sky130_fd_sc_hd__inv_2
XFILLER_0_78_565 VGND VGND VPWR VPWR sky130_fd_sc_hd__decap_8
XFILLER_0_93_546 VPWR VGND VPWR VGND sky130_ef_sc_hd__decap_12
XANTENNA__4637__RESET_B tree_instances\[0\].u_tree.rst_n VGND VGND VPWR VPWR sky130_fd_sc_hd__diode_2
XFILLER_0_18_175 VGND VGND VPWR VPWR sky130_fd_sc_hd__fill_2
Xclkload2 clknet_3_4__leaf_clk VGND VGND VPWR VPWR clkload2/Y sky130_fd_sc_hd__bufinv_16
XFILLER_0_46_495 VGND VGND VPWR VPWR sky130_fd_sc_hd__fill_1
XFILLER_0_61_498 VGND VGND VPWR VPWR sky130_fd_sc_hd__decap_6
XANTENNA_clkbuf_3_4__f_clk_A clknet_0_clk VGND VGND VPWR VPWR sky130_fd_sc_hd__diode_2
XANTENNA__4378__RESET_B net10 VGND VGND VPWR VPWR sky130_fd_sc_hd__diode_2
XFILLER_0_84_557 VPWR VGND VPWR VGND sky130_ef_sc_hd__decap_12
XTAP_TAPCELL_ROW_60_806 VGND VPWR sky130_fd_sc_hd__tapvpwrvgnd_1
XFILLER_0_71_229 VGND VGND VPWR VPWR sky130_fd_sc_hd__fill_2
XFILLER_0_21_24 VPWR VGND VPWR VGND sky130_ef_sc_hd__decap_12
XFILLER_0_52_421 VPWR VGND VPWR VGND sky130_ef_sc_hd__decap_12
X_2400_ _1560_ _1757_ _1572_ tree_instances\[12\].u_tree.tree_state\[2\] VGND VGND
+ VPWR VPWR _0007_ sky130_fd_sc_hd__o31a_1
X_3380_ tree_instances\[2\].u_tree.pipeline_frame_id\[0\]\[4\] _0682_ _0028_ VGND
+ VGND VPWR VPWR _0987_ sky130_fd_sc_hd__mux2_1
X_2331_ _1695_ _1696_ VGND VGND VPWR VPWR _1697_ sky130_fd_sc_hd__or2_1
X_2262_ _1636_ VGND VGND VPWR VPWR _1637_ sky130_fd_sc_hd__clkbuf_1
XANTENNA_clkbuf_leaf_41_clk_A clknet_3_7__leaf_clk VGND VGND VPWR VPWR sky130_fd_sc_hd__diode_2
X_4001_ _1735_ _1353_ VGND VGND VPWR VPWR _1362_ sky130_fd_sc_hd__and2_1
X_2193_ _1574_ VGND VGND VPWR VPWR _1575_ sky130_fd_sc_hd__buf_4
XANTENNA_clkbuf_leaf_56_clk_A clknet_3_4__leaf_clk VGND VGND VPWR VPWR sky130_fd_sc_hd__diode_2
XTAP_TAPCELL_ROW_76_972 VGND VPWR sky130_fd_sc_hd__tapvpwrvgnd_1
XTAP_TAPCELL_ROW_48_685 VGND VPWR sky130_fd_sc_hd__tapvpwrvgnd_1
XFILLER_0_75_535 VGND VGND VPWR VPWR sky130_fd_sc_hd__decap_4
XANTENNA__4730__RESET_B net10 VGND VGND VPWR VPWR sky130_fd_sc_hd__diode_2
XFILLER_0_62_97 VGND VGND VPWR VPWR sky130_fd_sc_hd__decap_8
XANTENNA__3091__A1 _0694_ VGND VGND VPWR VPWR sky130_fd_sc_hd__diode_2
X_4834_ clknet_leaf_48_clk _0516_ net10 VGND VGND VPWR VPWR tree_instances\[18\].u_tree.pipeline_frame_id\[0\]\[3\]
+ sky130_fd_sc_hd__dfrtp_1
X_4765_ clknet_leaf_39_clk _0065_ net10 VGND VGND VPWR VPWR tree_instances\[20\].u_tree.tree_state\[0\]
+ sky130_fd_sc_hd__dfstp_1
XFILLER_0_7_345 VGND VGND VPWR VPWR sky130_fd_sc_hd__fill_1
X_3716_ _1195_ VGND VGND VPWR VPWR _0308_ sky130_fd_sc_hd__clkbuf_1
XFILLER_0_55_281 VGND VGND VPWR VPWR sky130_fd_sc_hd__decap_8
X_4696_ clknet_leaf_71_clk _0399_ net9 VGND VGND VPWR VPWR tree_instances\[13\].u_tree.pipeline_current_node\[0\]\[0\]
+ sky130_fd_sc_hd__dfrtp_1
X_3647_ _1680_ _1139_ VGND VGND VPWR VPWR _1156_ sky130_fd_sc_hd__and2_1
XFILLER_0_3_573 VGND VGND VPWR VPWR sky130_fd_sc_hd__fill_1
X_3578_ _1109_ _1096_ VGND VGND VPWR VPWR _1110_ sky130_fd_sc_hd__and2_1
X_2529_ tree_instances\[3\].u_tree.tree_state\[3\] VGND VGND VPWR VPWR _1872_ sky130_fd_sc_hd__buf_2
XANTENNA__4889__RESET_B net12 VGND VGND VPWR VPWR sky130_fd_sc_hd__diode_2
XANTENNA__4818__RESET_B net11 VGND VGND VPWR VPWR sky130_fd_sc_hd__diode_2
XANTENNA__3082__A1 _0654_ VGND VGND VPWR VPWR sky130_fd_sc_hd__diode_2
XANTENNA__4471__RESET_B tree_instances\[0\].u_tree.rst_n VGND VGND VPWR VPWR sky130_fd_sc_hd__diode_2
XFILLER_0_38_215 VGND VGND VPWR VPWR sky130_fd_sc_hd__decap_6
XANTENNA__4400__RESET_B net11 VGND VGND VPWR VPWR sky130_fd_sc_hd__diode_2
XFILLER_0_19_440 VGND VGND VPWR VPWR sky130_fd_sc_hd__decap_8
XFILLER_0_93_398 VGND VGND VPWR VPWR sky130_fd_sc_hd__fill_1
XANTENNA__3909__A1 _1192_ VGND VGND VPWR VPWR sky130_fd_sc_hd__diode_2
XFILLER_0_19_473 VPWR VGND VPWR VGND sky130_ef_sc_hd__decap_12
XFILLER_0_34_421 VPWR VGND VPWR VGND sky130_ef_sc_hd__decap_12
XFILLER_0_46_281 VGND VGND VPWR VPWR sky130_fd_sc_hd__fill_1
XFILLER_0_21_104 VGND VGND VPWR VPWR sky130_fd_sc_hd__decap_8
XFILLER_0_21_137 VPWR VGND VPWR VGND sky130_ef_sc_hd__decap_12
XANTENNA__4559__RESET_B tree_instances\[0\].u_tree.rst_n VGND VGND VPWR VPWR sky130_fd_sc_hd__diode_2
XTAP_TAPCELL_ROW_73_942 VGND VPWR sky130_fd_sc_hd__tapvpwrvgnd_1
XFILLER_0_96_181 VPWR VGND VPWR VGND sky130_ef_sc_hd__decap_12
XFILLER_0_84_321 VGND VGND VPWR VPWR sky130_fd_sc_hd__decap_6
XANTENNA__3073__A1 _0714_ VGND VGND VPWR VPWR sky130_fd_sc_hd__diode_2
XFILLER_0_57_546 VGND VGND VPWR VPWR sky130_fd_sc_hd__fill_1
XTAP_TAPCELL_ROW_17_379 VGND VPWR sky130_fd_sc_hd__tapvpwrvgnd_1
XTAP_TAPCELL_ROW_45_655 VGND VPWR sky130_fd_sc_hd__tapvpwrvgnd_1
XFILLER_0_84_365 VPWR VGND VPWR VGND sky130_ef_sc_hd__decap_12
X_2880_ _0586_ VGND VGND VPWR VPWR _0587_ sky130_fd_sc_hd__clkbuf_1
XFILLER_0_37_281 VGND VGND VPWR VPWR sky130_fd_sc_hd__fill_2
X_4550_ clknet_leaf_47_clk _0017_ net13 VGND VGND VPWR VPWR tree_instances\[17\].u_tree.tree_state\[1\]
+ sky130_fd_sc_hd__dfrtp_1
X_3501_ _1056_ VGND VGND VPWR VPWR _1057_ sky130_fd_sc_hd__clkbuf_1
X_4481_ clknet_leaf_61_clk _0221_ tree_instances\[0\].u_tree.rst_n VGND VGND VPWR
+ VPWR tree_instances\[4\].u_tree.pipeline_frame_id\[0\]\[2\] sky130_fd_sc_hd__dfrtp_1
X_3432_ tree_instances\[3\].u_tree.frame_id_out\[3\] tree_instances\[3\].u_tree.pipeline_frame_id\[0\]\[3\]
+ _1872_ VGND VGND VPWR VPWR _1014_ sky130_fd_sc_hd__mux2_1
X_3363_ _0977_ VGND VGND VPWR VPWR _0173_ sky130_fd_sc_hd__clkbuf_1
X_3294_ tree_instances\[1\].u_tree.tree_state\[2\] tree_instances\[1\].u_tree.tree_state\[1\]
+ _0638_ VGND VGND VPWR VPWR _0935_ sky130_fd_sc_hd__or3_1
X_2314_ _1680_ _1681_ VGND VGND VPWR VPWR _1682_ sky130_fd_sc_hd__nor2_1
X_2245_ tree_instances\[17\].u_tree.pipeline_current_node\[0\]\[6\] VGND VGND VPWR
+ VPWR _1621_ sky130_fd_sc_hd__inv_2
X_2176_ tree_instances\[12\].u_tree.pipeline_current_node\[0\]\[3\] tree_instances\[12\].u_tree.pipeline_current_node\[0\]\[4\]
+ VGND VGND VPWR VPWR _1559_ sky130_fd_sc_hd__or2_1
XTAP_TAPCELL_ROW_0_203 VGND VPWR sky130_fd_sc_hd__tapvpwrvgnd_1
XFILLER_0_79_148 VGND VGND VPWR VPWR sky130_fd_sc_hd__fill_2
XTAP_TAPCELL_ROW_84_1049 VGND VPWR sky130_fd_sc_hd__tapvpwrvgnd_1
XANTENNA__3240__A _0686_ VGND VGND VPWR VPWR sky130_fd_sc_hd__diode_2
XFILLER_0_48_524 VGND VGND VPWR VPWR sky130_fd_sc_hd__decap_8
XFILLER_0_90_313 VPWR VGND VPWR VGND sky130_ef_sc_hd__decap_12
X_4817_ clknet_leaf_22_clk _0063_ net11 VGND VGND VPWR VPWR tree_instances\[1\].u_tree.tree_state\[0\]
+ sky130_fd_sc_hd__dfstp_1
XFILLER_0_75_376 VGND VGND VPWR VPWR sky130_fd_sc_hd__fill_2
Xclkbuf_leaf_60_clk clknet_3_1__leaf_clk VGND VGND VPWR VPWR clknet_leaf_60_clk sky130_fd_sc_hd__clkbuf_4
XFILLER_0_28_270 VPWR VGND VPWR VGND sky130_ef_sc_hd__decap_12
X_4748_ clknet_leaf_49_clk _0445_ net10 VGND VGND VPWR VPWR tree_instances\[15\].u_tree.pipeline_current_node\[0\]\[4\]
+ sky130_fd_sc_hd__dfrtp_1
X_4679_ clknet_leaf_17_clk _0383_ net11 VGND VGND VPWR VPWR tree_instances\[12\].u_tree.pipeline_current_node\[0\]\[5\]
+ sky130_fd_sc_hd__dfrtp_1
XTAP_TAPCELL_ROW_95_1156 VGND VPWR sky130_fd_sc_hd__tapvpwrvgnd_1
XPHY_EDGE_ROW_1_Right_1 VGND VGND VPWR VPWR sky130_fd_sc_hd__decap_3
XFILLER_0_11_181 VPWR VGND VPWR VGND sky130_ef_sc_hd__decap_12
XANTENNA__4652__RESET_B tree_instances\[0\].u_tree.rst_n VGND VGND VPWR VPWR sky130_fd_sc_hd__diode_2
XANTENNA__3150__A _0733_ VGND VGND VPWR VPWR sky130_fd_sc_hd__diode_2
XFILLER_0_78_170 VGND VGND VPWR VPWR sky130_fd_sc_hd__decap_8
XTAP_TAPCELL_ROW_70_912 VGND VPWR sky130_fd_sc_hd__tapvpwrvgnd_1
XFILLER_0_66_321 VGND VGND VPWR VPWR sky130_fd_sc_hd__decap_6
XFILLER_0_39_546 VGND VGND VPWR VPWR sky130_fd_sc_hd__fill_2
XTAP_TAPCELL_ROW_42_625 VGND VPWR sky130_fd_sc_hd__tapvpwrvgnd_1
XTAP_TAPCELL_ROW_14_349 VGND VPWR sky130_fd_sc_hd__tapvpwrvgnd_1
Xclkbuf_leaf_51_clk clknet_3_5__leaf_clk VGND VGND VPWR VPWR clknet_leaf_51_clk sky130_fd_sc_hd__clkbuf_4
XFILLER_0_19_281 VPWR VGND VPWR VGND sky130_ef_sc_hd__decap_12
XFILLER_0_94_29 VGND VGND VPWR VPWR sky130_fd_sc_hd__decap_6
XFILLER_0_89_457 VGND VGND VPWR VPWR sky130_fd_sc_hd__decap_3
XANTENNA__4393__RESET_B net11 VGND VGND VPWR VPWR sky130_fd_sc_hd__diode_2
XTAP_TAPCELL_ROW_58_791 VGND VPWR sky130_fd_sc_hd__tapvpwrvgnd_1
XANTENNA__3046__A1 _0704_ VGND VGND VPWR VPWR sky130_fd_sc_hd__diode_2
XANTENNA__3046__B2 _0690_ VGND VGND VPWR VPWR sky130_fd_sc_hd__diode_2
X_3981_ _1351_ VGND VGND VPWR VPWR _0417_ sky130_fd_sc_hd__clkbuf_1
XFILLER_0_9_429 VGND VGND VPWR VPWR sky130_fd_sc_hd__decap_8
X_2932_ _1765_ _1766_ VGND VGND VPWR VPWR _0625_ sky130_fd_sc_hd__nand2_1
XFILLER_0_84_173 VPWR VGND VPWR VGND sky130_ef_sc_hd__decap_12
XFILLER_0_17_218 VGND VGND VPWR VPWR sky130_fd_sc_hd__decap_6
Xclkbuf_leaf_42_clk clknet_3_7__leaf_clk VGND VGND VPWR VPWR clknet_leaf_42_clk sky130_fd_sc_hd__clkbuf_4
X_2863_ _2154_ VGND VGND VPWR VPWR _0570_ sky130_fd_sc_hd__clkbuf_1
XFILLER_0_60_508 VPWR VGND VPWR VGND sky130_ef_sc_hd__decap_12
X_4602_ clknet_leaf_70_clk _0317_ net9 VGND VGND VPWR VPWR tree_instances\[9\].u_tree.pipeline_current_node\[0\]\[3\]
+ sky130_fd_sc_hd__dfrtp_1
XFILLER_0_4_123 VGND VGND VPWR VPWR sky130_fd_sc_hd__fill_2
XFILLER_0_4_101 VGND VGND VPWR VPWR sky130_fd_sc_hd__fill_2
X_2794_ _2092_ VGND VGND VPWR VPWR _2099_ sky130_fd_sc_hd__clkbuf_1
X_4533_ clknet_leaf_19_clk _0263_ net11 VGND VGND VPWR VPWR tree_instances\[6\].u_tree.pipeline_frame_id\[0\]\[1\]
+ sky130_fd_sc_hd__dfrtp_1
XFILLER_0_13_435 VGND VGND VPWR VPWR sky130_fd_sc_hd__decap_8
XFILLER_0_13_402 VGND VGND VPWR VPWR sky130_fd_sc_hd__decap_4
XFILLER_0_80_390 VGND VGND VPWR VPWR sky130_fd_sc_hd__fill_2
XFILLER_0_13_446 VGND VGND VPWR VPWR sky130_fd_sc_hd__fill_2
XFILLER_0_68_63 VGND VGND VPWR VPWR sky130_fd_sc_hd__decap_8
XFILLER_0_7_55 VGND VGND VPWR VPWR sky130_fd_sc_hd__fill_1
X_4464_ clknet_leaf_62_clk _0205_ net9 VGND VGND VPWR VPWR tree_instances\[3\].u_tree.frame_id_out\[2\]
+ sky130_fd_sc_hd__dfrtp_1
X_4395_ clknet_leaf_30_clk _0143_ net11 VGND VGND VPWR VPWR tree_instances\[0\].u_tree.frame_id_out\[3\]
+ sky130_fd_sc_hd__dfrtp_1
X_3415_ _1005_ VGND VGND VPWR VPWR _0197_ sky130_fd_sc_hd__clkbuf_1
XFILLER_0_7_88 VGND VGND VPWR VPWR sky130_fd_sc_hd__decap_4
XFILLER_0_40_298 VGND VGND VPWR VPWR sky130_fd_sc_hd__decap_8
X_3346_ _0964_ VGND VGND VPWR VPWR _0169_ sky130_fd_sc_hd__clkbuf_1
X_3277_ _0926_ VGND VGND VPWR VPWR _0138_ sky130_fd_sc_hd__clkbuf_1
XFILLER_0_30_3 VGND VGND VPWR VPWR sky130_fd_sc_hd__fill_2
X_2228_ tree_instances\[11\].u_tree.pipeline_current_node\[0\]\[3\] VGND VGND VPWR
+ VPWR _1605_ sky130_fd_sc_hd__clkbuf_1
XFILLER_0_95_449 VPWR VGND VPWR VGND sky130_ef_sc_hd__decap_12
XANTENNA__3037__B2 _0704_ VGND VGND VPWR VPWR sky130_fd_sc_hd__diode_2
XANTENNA__3037__A1 _0647_ VGND VGND VPWR VPWR sky130_fd_sc_hd__diode_2
Xclkbuf_leaf_33_clk clknet_3_7__leaf_clk VGND VGND VPWR VPWR clknet_leaf_33_clk sky130_fd_sc_hd__clkbuf_4
XFILLER_0_75_173 VGND VGND VPWR VPWR sky130_fd_sc_hd__decap_6
XTAP_TAPCELL_ROW_11_319 VGND VPWR sky130_fd_sc_hd__tapvpwrvgnd_1
XFILLER_0_90_165 VGND VGND VPWR VPWR sky130_fd_sc_hd__decap_4
XANTENNA__4005__S _0012_ VGND VGND VPWR VPWR sky130_fd_sc_hd__diode_2
XFILLER_0_16_273 VGND VGND VPWR VPWR sky130_fd_sc_hd__fill_2
XFILLER_0_71_390 VGND VGND VPWR VPWR sky130_fd_sc_hd__fill_2
XFILLER_0_31_265 VPWR VGND VPWR VGND sky130_ef_sc_hd__decap_12
XFILLER_0_31_298 VPWR VGND VPWR VGND sky130_ef_sc_hd__decap_12
XANTENNA__2984__A _0661_ VGND VGND VPWR VPWR sky130_fd_sc_hd__diode_2
XANTENNA__4833__RESET_B net13 VGND VGND VPWR VPWR sky130_fd_sc_hd__diode_2
XANTENNA__3276__A1 _0925_ VGND VGND VPWR VPWR sky130_fd_sc_hd__diode_2
XANTENNA__3028__A1 _0658_ VGND VGND VPWR VPWR sky130_fd_sc_hd__diode_2
XFILLER_0_58_107 VPWR VGND VPWR VGND sky130_ef_sc_hd__decap_12
XFILLER_0_39_310 VGND VGND VPWR VPWR sky130_fd_sc_hd__decap_6
XTAP_TAPCELL_ROW_55_761 VGND VPWR sky130_fd_sc_hd__tapvpwrvgnd_1
XPHY_EDGE_ROW_17_Left_114 VGND VGND VPWR VPWR sky130_fd_sc_hd__decap_3
XTAP_TAPCELL_ROW_27_474 VGND VPWR sky130_fd_sc_hd__tapvpwrvgnd_1
Xclkbuf_leaf_24_clk clknet_3_3__leaf_clk VGND VGND VPWR VPWR clknet_leaf_24_clk sky130_fd_sc_hd__clkbuf_4
XFILLER_0_66_162 VPWR VGND VPWR VGND sky130_ef_sc_hd__decap_12
XFILLER_0_13_47 VGND VGND VPWR VPWR sky130_fd_sc_hd__fill_1
XFILLER_0_13_36 VGND VGND VPWR VPWR sky130_fd_sc_hd__fill_1
XFILLER_0_39_365 VGND VGND VPWR VPWR sky130_fd_sc_hd__decap_3
XFILLER_0_66_195 VGND VGND VPWR VPWR sky130_fd_sc_hd__fill_1
XFILLER_0_27_549 VGND VGND VPWR VPWR sky130_fd_sc_hd__decap_8
XFILLER_0_62_390 VGND VGND VPWR VPWR sky130_fd_sc_hd__fill_2
XANTENNA__3754__S _0042_ VGND VGND VPWR VPWR sky130_fd_sc_hd__diode_2
XFILLER_0_50_541 VGND VGND VPWR VPWR sky130_fd_sc_hd__fill_1
XFILLER_0_1_148 VGND VGND VPWR VPWR sky130_fd_sc_hd__fill_2
XPHY_EDGE_ROW_26_Left_123 VGND VGND VPWR VPWR sky130_fd_sc_hd__decap_3
X_3200_ _0654_ tree_instances\[5\].u_tree.frame_id_out\[2\] VGND VGND VPWR VPWR _0872_
+ sky130_fd_sc_hd__nand2_1
X_4180_ tree_instances\[17\].u_tree.frame_id_out\[0\] tree_instances\[17\].u_tree.pipeline_frame_id\[0\]\[0\]
+ _1827_ VGND VGND VPWR VPWR _1471_ sky130_fd_sc_hd__mux2_1
XANTENNA__3055__A _0726_ VGND VGND VPWR VPWR sky130_fd_sc_hd__diode_2
XANTENNA__4574__RESET_B net12 VGND VGND VPWR VPWR sky130_fd_sc_hd__diode_2
X_3131_ _0650_ tree_instances\[3\].u_tree.frame_id_out\[1\] VGND VGND VPWR VPWR _0803_
+ sky130_fd_sc_hd__xnor2_1
XANTENNA__4503__RESET_B net13 VGND VGND VPWR VPWR sky130_fd_sc_hd__diode_2
X_3062_ _0653_ tree_instances\[17\].u_tree.frame_id_out\[2\] VGND VGND VPWR VPWR _0734_
+ sky130_fd_sc_hd__xnor2_1
XFILLER_0_77_405 VPWR VGND VPWR VGND sky130_ef_sc_hd__decap_12
XFILLER_0_89_287 VGND VGND VPWR VPWR sky130_fd_sc_hd__fill_1
XPHY_EDGE_ROW_35_Left_132 VGND VGND VPWR VPWR sky130_fd_sc_hd__decap_3
XTAP_TAPCELL_ROW_81_1019 VGND VPWR sky130_fd_sc_hd__tapvpwrvgnd_1
Xclkbuf_leaf_15_clk clknet_3_2__leaf_clk VGND VGND VPWR VPWR clknet_leaf_15_clk sky130_fd_sc_hd__clkbuf_4
XFILLER_0_70_53 VGND VGND VPWR VPWR sky130_fd_sc_hd__decap_4
X_3964_ tree_instances\[13\].u_tree.pipeline_frame_id\[0\]\[1\] _1124_ _0010_ VGND
+ VGND VPWR VPWR _1343_ sky130_fd_sc_hd__mux2_1
X_3895_ _2021_ _1294_ VGND VGND VPWR VPWR _1300_ sky130_fd_sc_hd__and2_1
X_2915_ _0614_ VGND VGND VPWR VPWR _0002_ sky130_fd_sc_hd__inv_2
X_2846_ tree_instances\[20\].u_tree.pipeline_current_node\[0\]\[5\] VGND VGND VPWR
+ VPWR _2149_ sky130_fd_sc_hd__clkbuf_1
XFILLER_0_70_97 VPWR VGND VPWR VGND sky130_ef_sc_hd__decap_12
XFILLER_0_60_305 VGND VGND VPWR VPWR sky130_fd_sc_hd__decap_3
XFILLER_0_72_176 VGND VGND VPWR VPWR sky130_fd_sc_hd__fill_1
XFILLER_0_5_432 VPWR VGND VPWR VGND sky130_ef_sc_hd__decap_12
XFILLER_0_26_571 VGND VGND VPWR VPWR sky130_fd_sc_hd__decap_3
X_2777_ _2077_ VGND VGND VPWR VPWR _2085_ sky130_fd_sc_hd__clkbuf_1
XFILLER_0_78_3 VPWR VGND VPWR VGND sky130_ef_sc_hd__decap_12
XFILLER_0_60_349 VPWR VGND VPWR VGND sky130_ef_sc_hd__decap_12
XFILLER_0_13_232 VPWR VGND VPWR VGND sky130_ef_sc_hd__decap_12
XFILLER_0_41_552 VGND VGND VPWR VPWR sky130_fd_sc_hd__decap_8
XTAP_TAPCELL_ROW_92_1126 VGND VPWR sky130_fd_sc_hd__tapvpwrvgnd_1
XFILLER_0_79_84 VPWR VGND VPWR VGND sky130_ef_sc_hd__decap_12
X_4516_ clknet_leaf_61_clk _0247_ tree_instances\[0\].u_tree.rst_n VGND VGND VPWR
+ VPWR tree_instances\[5\].u_tree.frame_id_out\[2\] sky130_fd_sc_hd__dfrtp_1
XPHY_EDGE_ROW_44_Left_141 VGND VGND VPWR VPWR sky130_fd_sc_hd__decap_3
X_4447_ clknet_leaf_43_clk _0188_ net10 VGND VGND VPWR VPWR tree_instances\[14\].u_tree.pipeline_valid\[0\]
+ sky130_fd_sc_hd__dfrtp_1
XFILLER_0_0_181 VPWR VGND VPWR VGND sky130_ef_sc_hd__decap_12
X_4378_ clknet_leaf_37_clk _0126_ net10 VGND VGND VPWR VPWR tree_instances\[0\].u_tree.pipeline_current_node\[0\]\[0\]
+ sky130_fd_sc_hd__dfrtp_1
X_3329_ _0953_ VGND VGND VPWR VPWR _0163_ sky130_fd_sc_hd__clkbuf_1
XTAP_TAPCELL_ROW_69_897 VGND VPWR sky130_fd_sc_hd__tapvpwrvgnd_1
XPHY_EDGE_ROW_53_Left_150 VGND VGND VPWR VPWR sky130_fd_sc_hd__decap_3
XFILLER_0_95_202 VPWR VGND VPWR VGND sky130_ef_sc_hd__decap_12
XFILLER_0_68_427 VGND VGND VPWR VPWR sky130_fd_sc_hd__fill_1
XTAP_TAPCELL_ROW_24_444 VGND VPWR sky130_fd_sc_hd__tapvpwrvgnd_1
XTAP_TAPCELL_ROW_52_731 VGND VPWR sky130_fd_sc_hd__tapvpwrvgnd_1
XFILLER_0_91_452 VPWR VGND VPWR VGND sky130_ef_sc_hd__decap_12
XANTENNA__2979__A _0657_ VGND VGND VPWR VPWR sky130_fd_sc_hd__diode_2
XFILLER_0_51_349 VGND VGND VPWR VPWR sky130_fd_sc_hd__fill_1
XFILLER_0_59_405 VGND VGND VPWR VPWR sky130_fd_sc_hd__fill_2
XFILLER_0_59_449 VGND VGND VPWR VPWR sky130_fd_sc_hd__fill_2
XFILLER_0_24_35 VGND VGND VPWR VPWR sky130_fd_sc_hd__fill_1
XFILLER_0_24_79 VGND VGND VPWR VPWR sky130_fd_sc_hd__fill_2
XFILLER_0_67_493 VGND VGND VPWR VPWR sky130_fd_sc_hd__decap_8
XFILLER_0_6_207 VGND VGND VPWR VPWR sky130_fd_sc_hd__fill_1
X_2700_ _2014_ VGND VGND VPWR VPWR _2019_ sky130_fd_sc_hd__clkbuf_1
XFILLER_0_40_45 VPWR VGND VPWR VGND sky130_ef_sc_hd__decap_12
X_3680_ tree_instances\[7\].u_tree.tree_state\[3\] _1687_ _0616_ tree_instances\[7\].u_tree.ready_for_next
+ VGND VGND VPWR VPWR _0293_ sky130_fd_sc_hd__a22o_1
XFILLER_0_42_316 VGND VGND VPWR VPWR sky130_fd_sc_hd__fill_2
XFILLER_0_2_413 VGND VGND VPWR VPWR sky130_fd_sc_hd__decap_6
XFILLER_0_23_541 VPWR VGND VPWR VGND sky130_ef_sc_hd__decap_12
XFILLER_0_35_390 VGND VGND VPWR VPWR sky130_fd_sc_hd__fill_2
X_2631_ _1956_ VGND VGND VPWR VPWR _1957_ sky130_fd_sc_hd__clkbuf_1
X_2562_ _1899_ VGND VGND VPWR VPWR _1900_ sky130_fd_sc_hd__clkbuf_1
X_4301_ _1533_ VGND VGND VPWR VPWR _0555_ sky130_fd_sc_hd__clkbuf_1
XANTENNA__4755__RESET_B net10 VGND VGND VPWR VPWR sky130_fd_sc_hd__diode_2
XFILLER_0_49_32 VGND VGND VPWR VPWR sky130_fd_sc_hd__fill_2
XFILLER_0_10_257 VGND VGND VPWR VPWR sky130_fd_sc_hd__decap_6
X_2493_ tree_instances\[3\].u_tree.pipeline_current_node\[0\]\[0\] VGND VGND VPWR
+ VPWR _1839_ sky130_fd_sc_hd__clkbuf_1
X_4232_ _1497_ VGND VGND VPWR VPWR _0522_ sky130_fd_sc_hd__clkbuf_1
Xclkbuf_leaf_4_clk clknet_3_0__leaf_clk VGND VGND VPWR VPWR clknet_leaf_4_clk sky130_fd_sc_hd__clkbuf_4
XFILLER_0_65_42 VGND VGND VPWR VPWR sky130_fd_sc_hd__decap_3
X_4163_ _1461_ VGND VGND VPWR VPWR _1462_ sky130_fd_sc_hd__clkbuf_1
X_3114_ tree_instances\[4\].u_tree.frame_id_out\[3\] VGND VGND VPWR VPWR _0786_ sky130_fd_sc_hd__inv_2
X_4094_ tree_instances\[16\].u_tree.pipeline_frame_id\[0\]\[1\] _0672_ _0016_ VGND
+ VGND VPWR VPWR _1410_ sky130_fd_sc_hd__mux2_1
X_3045_ _0650_ tree_instances\[14\].u_tree.frame_id_out\[1\] VGND VGND VPWR VPWR _0717_
+ sky130_fd_sc_hd__xnor2_1
XTAP_TAPCELL_ROW_66_867 VGND VPWR sky130_fd_sc_hd__tapvpwrvgnd_1
XFILLER_0_77_257 VGND VGND VPWR VPWR sky130_fd_sc_hd__decap_3
XANTENNA__3660__A1 _1124_ VGND VGND VPWR VPWR sky130_fd_sc_hd__diode_2
X_3947_ _1334_ VGND VGND VPWR VPWR _0400_ sky130_fd_sc_hd__clkbuf_1
XTAP_TAPCELL_ROW_21_414 VGND VPWR sky130_fd_sc_hd__tapvpwrvgnd_1
X_3878_ _1282_ VGND VGND VPWR VPWR _1288_ sky130_fd_sc_hd__clkbuf_1
XFILLER_0_45_187 VGND VGND VPWR VPWR sky130_fd_sc_hd__decap_6
X_2829_ tree_instances\[0\].u_tree.pipeline_current_node\[0\]\[8\] VGND VGND VPWR
+ VPWR _2132_ sky130_fd_sc_hd__clkbuf_1
XFILLER_0_41_393 VPWR VGND VPWR VGND sky130_ef_sc_hd__decap_12
XANTENNA__4425__RESET_B tree_instances\[0\].u_tree.rst_n VGND VGND VPWR VPWR sky130_fd_sc_hd__diode_2
XTAP_TAPCELL_ROW_29_503 VGND VPWR sky130_fd_sc_hd__tapvpwrvgnd_1
XFILLER_0_96_533 VPWR VGND VPWR VGND sky130_ef_sc_hd__decap_12
XFILLER_0_68_279 VGND VGND VPWR VPWR sky130_fd_sc_hd__fill_2
XTAP_TAPCELL_ROW_37_580 VGND VPWR sky130_fd_sc_hd__tapvpwrvgnd_1
XFILLER_0_56_419 VGND VGND VPWR VPWR sky130_fd_sc_hd__fill_1
XFILLER_0_83_249 VGND VGND VPWR VPWR sky130_fd_sc_hd__decap_3
XFILLER_0_49_482 VGND VGND VPWR VPWR sky130_fd_sc_hd__fill_2
XFILLER_0_64_430 VGND VGND VPWR VPWR sky130_fd_sc_hd__fill_2
XFILLER_0_36_176 VGND VGND VPWR VPWR sky130_fd_sc_hd__fill_2
XFILLER_0_51_113 VPWR VGND VPWR VGND sky130_ef_sc_hd__decap_12
XFILLER_0_91_293 VPWR VGND VPWR VGND sky130_ef_sc_hd__decap_12
XFILLER_0_10_15 VPWR VGND VPWR VGND sky130_ef_sc_hd__decap_12
XTAP_TAPCELL_ROW_9_294 VGND VPWR sky130_fd_sc_hd__tapvpwrvgnd_1
XFILLER_0_19_57 VPWR VGND VPWR VGND sky130_ef_sc_hd__decap_12
Xclkbuf_3_7__f_clk clknet_0_clk VGND VGND VPWR VPWR clknet_3_7__leaf_clk sky130_fd_sc_hd__clkbuf_16
XTAP_TAPCELL_ROW_63_837 VGND VPWR sky130_fd_sc_hd__tapvpwrvgnd_1
X_4850_ clknet_leaf_32_clk _0531_ net13 VGND VGND VPWR VPWR tree_instances\[19\].u_tree.pipeline_current_node\[0\]\[5\]
+ sky130_fd_sc_hd__dfrtp_1
XFILLER_0_59_279 VGND VGND VPWR VPWR sky130_fd_sc_hd__fill_1
XFILLER_0_59_268 VGND VGND VPWR VPWR sky130_fd_sc_hd__decap_4
XANTENNA_clkbuf_leaf_0_clk_A clknet_3_0__leaf_clk VGND VGND VPWR VPWR sky130_fd_sc_hd__diode_2
XFILLER_0_74_238 VGND VGND VPWR VPWR sky130_fd_sc_hd__fill_2
XFILLER_0_7_505 VPWR VGND VPWR VGND sky130_ef_sc_hd__decap_12
X_3801_ _1243_ VGND VGND VPWR VPWR _0345_ sky130_fd_sc_hd__clkbuf_1
XANTENNA__3395__A1_N _1889_ VGND VGND VPWR VPWR sky130_fd_sc_hd__diode_2
XFILLER_0_67_290 VGND VGND VPWR VPWR sky130_fd_sc_hd__fill_2
XFILLER_0_27_121 VGND VGND VPWR VPWR sky130_fd_sc_hd__fill_1
X_4781_ clknet_leaf_51_clk _0469_ net13 VGND VGND VPWR VPWR tree_instances\[16\].u_tree.pipeline_current_node\[0\]\[7\]
+ sky130_fd_sc_hd__dfrtp_1
XFILLER_0_51_55 VGND VGND VPWR VPWR sky130_fd_sc_hd__fill_1
X_3732_ _1589_ VGND VGND VPWR VPWR _1206_ sky130_fd_sc_hd__clkbuf_1
Xclkload20 clknet_leaf_67_clk VGND VGND VPWR VPWR clkload20/Y sky130_fd_sc_hd__clkinvlp_4
X_3663_ tree_instances\[7\].u_tree.pipeline_frame_id\[0\]\[2\] _1165_ _0038_ VGND
+ VGND VPWR VPWR _1166_ sky130_fd_sc_hd__mux2_1
X_2614_ _1939_ _1941_ VGND VGND VPWR VPWR _1942_ sky130_fd_sc_hd__or2_1
Xclkload53 clknet_leaf_28_clk VGND VGND VPWR VPWR clkload53/Y sky130_fd_sc_hd__bufinv_16
XFILLER_0_70_488 VGND VGND VPWR VPWR sky130_fd_sc_hd__fill_1
Xclkload31 clknet_leaf_8_clk VGND VGND VPWR VPWR clkload31/Y sky130_fd_sc_hd__bufinv_16
Xclkload42 clknet_leaf_59_clk VGND VGND VPWR VPWR clkload42/Y sky130_fd_sc_hd__clkinvlp_4
X_3594_ _1121_ VGND VGND VPWR VPWR _0260_ sky130_fd_sc_hd__clkbuf_1
Xclkload64 clknet_leaf_39_clk VGND VGND VPWR VPWR clkload64/Y sky130_fd_sc_hd__clkinv_1
XFILLER_0_23_393 VPWR VGND VPWR VGND sky130_ef_sc_hd__decap_12
X_2545_ _1885_ VGND VGND VPWR VPWR _1886_ sky130_fd_sc_hd__clkbuf_1
X_2476_ tree_instances\[0\].u_tree.tree_state\[2\] _1644_ VGND VGND VPWR VPWR _1826_
+ sky130_fd_sc_hd__and2_1
XFILLER_0_76_74 VGND VGND VPWR VPWR sky130_fd_sc_hd__decap_8
X_4215_ tree_instances\[18\].u_tree.pipeline_frame_id\[0\]\[1\] _0672_ _0020_ VGND
+ VGND VPWR VPWR _1489_ sky130_fd_sc_hd__mux2_1
X_4146_ _1448_ VGND VGND VPWR VPWR _0485_ sky130_fd_sc_hd__clkbuf_1
X_4077_ _1401_ VGND VGND VPWR VPWR _0463_ sky130_fd_sc_hd__clkbuf_1
XFILLER_0_78_533 VPWR VGND VPWR VGND sky130_ef_sc_hd__decap_12
X_3028_ _0658_ _0688_ _0693_ _0699_ VGND VGND VPWR VPWR _0700_ sky130_fd_sc_hd__a211o_1
XFILLER_0_65_238 VGND VGND VPWR VPWR sky130_fd_sc_hd__decap_6
XFILLER_0_18_110 VGND VGND VPWR VPWR sky130_fd_sc_hd__fill_2
XTAP_TAPCELL_ROW_34_550 VGND VPWR sky130_fd_sc_hd__tapvpwrvgnd_1
XFILLER_0_93_558 VGND VGND VPWR VPWR sky130_fd_sc_hd__fill_2
Xclkload3 clknet_3_5__leaf_clk VGND VGND VPWR VPWR clkload3/Y sky130_fd_sc_hd__inv_2
XFILLER_0_46_463 VGND VGND VPWR VPWR sky130_fd_sc_hd__fill_1
XANTENNA__4677__RESET_B net11 VGND VGND VPWR VPWR sky130_fd_sc_hd__diode_2
XFILLER_0_61_422 VGND VGND VPWR VPWR sky130_fd_sc_hd__decap_6
XFILLER_0_33_113 VGND VGND VPWR VPWR sky130_fd_sc_hd__decap_8
XANTENNA__4013__S _0012_ VGND VGND VPWR VPWR sky130_fd_sc_hd__diode_2
XANTENNA__4606__RESET_B net9 VGND VGND VPWR VPWR sky130_fd_sc_hd__diode_2
XTAP_TAPCELL_ROW_6_264 VGND VPWR sky130_fd_sc_hd__tapvpwrvgnd_1
XANTENNA__2992__A net1 VGND VGND VPWR VPWR sky130_fd_sc_hd__diode_2
XFILLER_0_69_533 VPWR VGND VPWR VGND sky130_ef_sc_hd__decap_12
XTAP_TAPCELL_ROW_60_807 VGND VPWR sky130_fd_sc_hd__tapvpwrvgnd_1
XFILLER_0_84_569 VGND VGND VPWR VPWR sky130_fd_sc_hd__decap_4
XFILLER_0_21_36 VPWR VGND VPWR VGND sky130_ef_sc_hd__decap_12
XFILLER_0_52_433 VPWR VGND VPWR VGND sky130_ef_sc_hd__decap_12
XFILLER_0_24_179 VGND VGND VPWR VPWR sky130_fd_sc_hd__decap_6
XANTENNA__4347__RESET_B tree_instances\[0\].u_tree.rst_n VGND VGND VPWR VPWR sky130_fd_sc_hd__diode_2
XFILLER_0_52_488 VPWR VGND VPWR VGND sky130_ef_sc_hd__decap_12
XFILLER_0_20_352 VGND VGND VPWR VPWR sky130_fd_sc_hd__fill_2
XANTENNA__3762__S _0042_ VGND VGND VPWR VPWR sky130_fd_sc_hd__diode_2
X_2330_ tree_instances\[15\].u_tree.pipeline_current_node\[0\]\[7\] tree_instances\[15\].u_tree.pipeline_current_node\[0\]\[6\]
+ VGND VGND VPWR VPWR _1696_ sky130_fd_sc_hd__or2_1
X_2261_ tree_instances\[0\].u_tree.pipeline_current_node\[0\]\[8\] tree_instances\[0\].u_tree.pipeline_current_node\[0\]\[7\]
+ VGND VGND VPWR VPWR _1636_ sky130_fd_sc_hd__or2_1
X_4000_ _1361_ VGND VGND VPWR VPWR _0426_ sky130_fd_sc_hd__clkbuf_1
X_2192_ net1 VGND VGND VPWR VPWR _1574_ sky130_fd_sc_hd__inv_2
XFILLER_0_46_55 VGND VGND VPWR VPWR sky130_fd_sc_hd__fill_1
XTAP_TAPCELL_ROW_76_973 VGND VPWR sky130_fd_sc_hd__tapvpwrvgnd_1
XPHY_EDGE_ROW_9_Left_106 VGND VGND VPWR VPWR sky130_fd_sc_hd__decap_3
XTAP_TAPCELL_ROW_48_686 VGND VPWR sky130_fd_sc_hd__tapvpwrvgnd_1
XFILLER_0_87_341 VGND VGND VPWR VPWR sky130_fd_sc_hd__fill_2
XFILLER_0_1_57 VPWR VGND VPWR VGND sky130_ef_sc_hd__decap_12
XFILLER_0_75_558 VGND VGND VPWR VPWR sky130_fd_sc_hd__fill_2
XFILLER_0_28_441 VGND VGND VPWR VPWR sky130_fd_sc_hd__fill_2
X_4833_ clknet_leaf_46_clk _0515_ net13 VGND VGND VPWR VPWR tree_instances\[18\].u_tree.pipeline_frame_id\[0\]\[2\]
+ sky130_fd_sc_hd__dfrtp_1
XFILLER_0_7_335 VGND VGND VPWR VPWR sky130_fd_sc_hd__fill_1
XTAP_TAPCELL_ROW_31_520 VGND VPWR sky130_fd_sc_hd__tapvpwrvgnd_1
X_4764_ clknet_leaf_45_clk _0091_ net11 VGND VGND VPWR VPWR tree_instances\[15\].u_tree.prediction_valid
+ sky130_fd_sc_hd__dfrtp_1
X_3715_ tree_instances\[8\].u_tree.frame_id_out\[0\] tree_instances\[8\].u_tree.pipeline_frame_id\[0\]\[0\]
+ _1668_ VGND VGND VPWR VPWR _1195_ sky130_fd_sc_hd__mux2_1
XFILLER_0_15_113 VGND VGND VPWR VPWR sky130_fd_sc_hd__decap_8
XFILLER_0_15_124 VPWR VGND VPWR VGND sky130_ef_sc_hd__decap_12
XFILLER_0_43_422 VGND VGND VPWR VPWR sky130_fd_sc_hd__fill_2
XANTENNA__4770__RESET_B net10 VGND VGND VPWR VPWR sky130_fd_sc_hd__diode_2
X_4695_ clknet_leaf_57_clk _0398_ net13 VGND VGND VPWR VPWR tree_instances\[5\].u_tree.pipeline_valid\[0\]
+ sky130_fd_sc_hd__dfrtp_1
XANTENNA__3238__A _0726_ VGND VGND VPWR VPWR sky130_fd_sc_hd__diode_2
X_3646_ _1155_ VGND VGND VPWR VPWR _0278_ sky130_fd_sc_hd__clkbuf_1
XFILLER_0_3_541 VPWR VGND VPWR VGND sky130_ef_sc_hd__decap_12
XFILLER_0_30_105 VGND VGND VPWR VPWR sky130_fd_sc_hd__decap_3
XFILLER_0_30_127 VGND VGND VPWR VPWR sky130_fd_sc_hd__fill_2
X_3577_ _1108_ VGND VGND VPWR VPWR _1109_ sky130_fd_sc_hd__clkbuf_1
XFILLER_0_87_40 VGND VGND VPWR VPWR sky130_fd_sc_hd__fill_2
X_2528_ _1666_ tree_instances\[3\].u_tree.pipeline_valid\[0\] VGND VGND VPWR VPWR
+ _1871_ sky130_fd_sc_hd__or2_1
X_2459_ _1809_ VGND VGND VPWR VPWR _1810_ sky130_fd_sc_hd__clkbuf_1
XTAP_TAPCELL_ROW_3_234 VGND VPWR sky130_fd_sc_hd__tapvpwrvgnd_1
X_4129_ _1953_ VGND VGND VPWR VPWR _1435_ sky130_fd_sc_hd__clkbuf_1
XANTENNA__3606__A1 _0682_ VGND VGND VPWR VPWR sky130_fd_sc_hd__diode_2
XFILLER_0_78_363 VGND VGND VPWR VPWR sky130_fd_sc_hd__fill_1
XANTENNA__4858__RESET_B net10 VGND VGND VPWR VPWR sky130_fd_sc_hd__diode_2
XFILLER_0_81_528 VGND VGND VPWR VPWR sky130_fd_sc_hd__decap_6
XFILLER_0_81_517 VGND VGND VPWR VPWR sky130_fd_sc_hd__fill_2
XFILLER_0_19_485 VGND VGND VPWR VPWR sky130_fd_sc_hd__decap_8
XFILLER_0_34_433 VGND VGND VPWR VPWR sky130_fd_sc_hd__decap_6
XANTENNA__3148__A _0662_ VGND VGND VPWR VPWR sky130_fd_sc_hd__diode_2
XFILLER_0_61_241 VGND VGND VPWR VPWR sky130_fd_sc_hd__decap_3
XANTENNA__4440__RESET_B net13 VGND VGND VPWR VPWR sky130_fd_sc_hd__diode_2
XFILLER_0_34_455 VGND VGND VPWR VPWR sky130_fd_sc_hd__fill_2
XFILLER_0_34_477 VPWR VGND VPWR VGND sky130_ef_sc_hd__decap_12
XFILLER_0_21_149 VPWR VGND VPWR VGND sky130_ef_sc_hd__decap_12
XANTENNA__4098__A1 _0678_ VGND VGND VPWR VPWR sky130_fd_sc_hd__diode_2
XTAP_TAPCELL_ROW_73_943 VGND VPWR sky130_fd_sc_hd__tapvpwrvgnd_1
XANTENNA__4593__SET_B net12 VGND VGND VPWR VPWR sky130_fd_sc_hd__diode_2
XFILLER_0_84_300 VGND VGND VPWR VPWR sky130_fd_sc_hd__decap_8
XANTENNA__4599__RESET_B net9 VGND VGND VPWR VPWR sky130_fd_sc_hd__diode_2
XFILLER_0_29_205 VPWR VGND VPWR VGND sky130_ef_sc_hd__decap_12
XTAP_TAPCELL_ROW_45_656 VGND VPWR sky130_fd_sc_hd__tapvpwrvgnd_1
XFILLER_0_96_193 VGND VGND VPWR VPWR sky130_fd_sc_hd__decap_3
XFILLER_0_57_558 VGND VGND VPWR VPWR sky130_fd_sc_hd__fill_2
XFILLER_0_32_24 VGND VGND VPWR VPWR sky130_fd_sc_hd__fill_1
XANTENNA__4528__RESET_B net11 VGND VGND VPWR VPWR sky130_fd_sc_hd__diode_2
XFILLER_0_84_377 VPWR VGND VPWR VGND sky130_ef_sc_hd__decap_12
XFILLER_0_72_517 VPWR VGND VPWR VGND sky130_ef_sc_hd__decap_12
X_3500_ tree_instances\[5\].u_tree.pipeline_current_node\[0\]\[1\] VGND VGND VPWR
+ VPWR _1056_ sky130_fd_sc_hd__clkbuf_1
X_4480_ clknet_leaf_61_clk _0220_ tree_instances\[0\].u_tree.rst_n VGND VGND VPWR
+ VPWR tree_instances\[4\].u_tree.pipeline_frame_id\[0\]\[1\] sky130_fd_sc_hd__dfrtp_1
XFILLER_0_40_425 VPWR VGND VPWR VGND sky130_ef_sc_hd__decap_12
X_3431_ _1013_ VGND VGND VPWR VPWR _0205_ sky130_fd_sc_hd__clkbuf_1
XFILLER_0_40_469 VGND VGND VPWR VPWR sky130_fd_sc_hd__decap_4
XFILLER_0_0_533 VPWR VGND VPWR VGND sky130_ef_sc_hd__decap_12
X_3362_ _0976_ _0960_ VGND VGND VPWR VPWR _0977_ sky130_fd_sc_hd__and2_1
X_2313_ tree_instances\[7\].u_tree.pipeline_current_node\[0\]\[6\] VGND VGND VPWR
+ VPWR _1681_ sky130_fd_sc_hd__clkbuf_1
X_3293_ _1827_ _0934_ _0018_ tree_instances\[17\].u_tree.pipeline_valid\[0\] VGND
+ VGND VPWR VPWR _0146_ sky130_fd_sc_hd__o2bb2a_1
X_2244_ _1619_ VGND VGND VPWR VPWR _1620_ sky130_fd_sc_hd__clkbuf_1
X_2175_ _1557_ VGND VGND VPWR VPWR _1558_ sky130_fd_sc_hd__clkbuf_1
XFILLER_0_73_31 VGND VGND VPWR VPWR sky130_fd_sc_hd__fill_1
XTAP_TAPCELL_ROW_0_204 VGND VPWR sky130_fd_sc_hd__tapvpwrvgnd_1
XANTENNA__3240__B _0649_ VGND VGND VPWR VPWR sky130_fd_sc_hd__diode_2
XANTENNA__4261__A1 _0672_ VGND VGND VPWR VPWR sky130_fd_sc_hd__diode_2
XFILLER_0_75_344 VPWR VGND VPWR VGND sky130_ef_sc_hd__decap_12
XFILLER_0_63_528 VGND VGND VPWR VPWR sky130_fd_sc_hd__fill_2
XFILLER_0_7_110 VGND VGND VPWR VPWR sky130_fd_sc_hd__fill_2
X_4816_ clknet_leaf_59_clk _0093_ net12 VGND VGND VPWR VPWR tree_instances\[17\].u_tree.prediction_valid
+ sky130_fd_sc_hd__dfrtp_1
XFILLER_0_90_325 VPWR VGND VPWR VGND sky130_ef_sc_hd__decap_12
XANTENNA__4013__A1 _1168_ VGND VGND VPWR VPWR sky130_fd_sc_hd__diode_2
XFILLER_0_28_282 VGND VGND VPWR VPWR sky130_fd_sc_hd__decap_6
XFILLER_0_71_561 VPWR VGND VPWR VGND sky130_ef_sc_hd__decap_12
XFILLER_0_16_444 VGND VGND VPWR VPWR sky130_fd_sc_hd__fill_2
X_4747_ clknet_leaf_41_clk _0444_ net10 VGND VGND VPWR VPWR tree_instances\[15\].u_tree.pipeline_current_node\[0\]\[3\]
+ sky130_fd_sc_hd__dfrtp_1
X_4678_ clknet_leaf_17_clk _0382_ net12 VGND VGND VPWR VPWR tree_instances\[12\].u_tree.pipeline_current_node\[0\]\[4\]
+ sky130_fd_sc_hd__dfrtp_1
XFILLER_0_43_263 VGND VGND VPWR VPWR sky130_fd_sc_hd__fill_2
XFILLER_0_43_274 VGND VGND VPWR VPWR sky130_fd_sc_hd__decap_6
XTAP_TAPCELL_ROW_95_1157 VGND VPWR sky130_fd_sc_hd__tapvpwrvgnd_1
X_3629_ _1141_ VGND VGND VPWR VPWR _1142_ sky130_fd_sc_hd__clkbuf_1
XFILLER_0_31_447 VGND VGND VPWR VPWR sky130_fd_sc_hd__fill_1
XFILLER_0_3_393 VPWR VGND VPWR VGND sky130_ef_sc_hd__decap_12
XFILLER_0_11_193 VPWR VGND VPWR VGND sky130_ef_sc_hd__decap_12
XTAP_TAPCELL_ROW_70_913 VGND VPWR sky130_fd_sc_hd__tapvpwrvgnd_1
XFILLER_0_39_503 VGND VGND VPWR VPWR sky130_fd_sc_hd__fill_1
XANTENNA__4692__RESET_B net11 VGND VGND VPWR VPWR sky130_fd_sc_hd__diode_2
XFILLER_0_66_355 VGND VGND VPWR VPWR sky130_fd_sc_hd__fill_2
XTAP_TAPCELL_ROW_42_626 VGND VPWR sky130_fd_sc_hd__tapvpwrvgnd_1
XANTENNA__4621__RESET_B net10 VGND VGND VPWR VPWR sky130_fd_sc_hd__diode_2
XFILLER_0_66_377 VGND VGND VPWR VPWR sky130_fd_sc_hd__fill_1
XANTENNA_clkbuf_leaf_40_clk_A clknet_3_7__leaf_clk VGND VGND VPWR VPWR sky130_fd_sc_hd__diode_2
XFILLER_0_19_293 VPWR VGND VPWR VGND sky130_ef_sc_hd__decap_12
XFILLER_0_34_263 VGND VGND VPWR VPWR sky130_fd_sc_hd__fill_2
XANTENNA_clkbuf_leaf_55_clk_A clknet_3_4__leaf_clk VGND VGND VPWR VPWR sky130_fd_sc_hd__diode_2
XFILLER_0_1_308 VPWR VGND VPWR VGND sky130_ef_sc_hd__decap_12
XFILLER_0_94_19 VGND VGND VPWR VPWR sky130_fd_sc_hd__decap_8
XFILLER_0_27_57 VPWR VGND VPWR VGND sky130_ef_sc_hd__decap_12
XFILLER_0_89_447 VGND VGND VPWR VPWR sky130_fd_sc_hd__fill_1
XTAP_TAPCELL_ROW_58_792 VGND VPWR sky130_fd_sc_hd__tapvpwrvgnd_1
XANTENNA__4709__RESET_B net9 VGND VGND VPWR VPWR sky130_fd_sc_hd__diode_2
XFILLER_0_76_119 VGND VGND VPWR VPWR sky130_fd_sc_hd__fill_1
X_3980_ tree_instances\[13\].u_tree.frame_id_out\[4\] tree_instances\[13\].u_tree.pipeline_frame_id\[0\]\[4\]
+ tree_instances\[13\].u_tree.tree_state\[3\] VGND VGND VPWR VPWR _1351_ sky130_fd_sc_hd__mux2_1
X_2931_ _0624_ VGND VGND VPWR VPWR _0034_ sky130_fd_sc_hd__inv_2
XFILLER_0_84_141 VGND VGND VPWR VPWR sky130_fd_sc_hd__decap_8
XFILLER_0_57_388 VGND VGND VPWR VPWR sky130_fd_sc_hd__fill_2
XFILLER_0_45_528 VGND VGND VPWR VPWR sky130_fd_sc_hd__decap_8
XANTENNA__4362__RESET_B net12 VGND VGND VPWR VPWR sky130_fd_sc_hd__diode_2
Xclkbuf_0_clk net15 VGND VGND VPWR VPWR clknet_0_clk sky130_fd_sc_hd__clkbuf_16
X_2862_ _2157_ VGND VGND VPWR VPWR _0569_ sky130_fd_sc_hd__clkbuf_1
XFILLER_0_84_185 VGND VGND VPWR VPWR sky130_fd_sc_hd__decap_8
X_4601_ clknet_leaf_0_clk _0316_ net9 VGND VGND VPWR VPWR tree_instances\[9\].u_tree.pipeline_current_node\[0\]\[2\]
+ sky130_fd_sc_hd__dfrtp_1
XFILLER_0_72_369 VGND VGND VPWR VPWR sky130_fd_sc_hd__fill_1
XFILLER_0_72_358 VGND VGND VPWR VPWR sky130_fd_sc_hd__decap_6
X_2793_ tree_instances\[4\].u_tree.pipeline_current_node\[0\]\[8\] VGND VGND VPWR
+ VPWR _2098_ sky130_fd_sc_hd__clkbuf_1
XFILLER_0_53_550 VGND VGND VPWR VPWR sky130_fd_sc_hd__decap_8
XFILLER_0_53_561 VPWR VGND VPWR VGND sky130_ef_sc_hd__decap_12
X_4532_ clknet_leaf_23_clk _0262_ net11 VGND VGND VPWR VPWR tree_instances\[6\].u_tree.pipeline_frame_id\[0\]\[0\]
+ sky130_fd_sc_hd__dfrtp_1
XFILLER_0_4_146 VGND VGND VPWR VPWR sky130_fd_sc_hd__decap_4
XFILLER_0_4_135 VGND VGND VPWR VPWR sky130_fd_sc_hd__fill_2
X_4463_ clknet_leaf_62_clk _0204_ net9 VGND VGND VPWR VPWR tree_instances\[3\].u_tree.frame_id_out\[1\]
+ sky130_fd_sc_hd__dfrtp_1
XFILLER_0_40_244 VGND VGND VPWR VPWR sky130_fd_sc_hd__fill_2
X_3414_ _1909_ _0995_ VGND VGND VPWR VPWR _1005_ sky130_fd_sc_hd__and2_1
X_4394_ clknet_leaf_29_clk _0142_ net13 VGND VGND VPWR VPWR tree_instances\[0\].u_tree.frame_id_out\[2\]
+ sky130_fd_sc_hd__dfrtp_1
XPHY_EDGE_ROW_15_Right_15 VGND VGND VPWR VPWR sky130_fd_sc_hd__decap_3
X_3345_ _0963_ _0960_ VGND VGND VPWR VPWR _0964_ sky130_fd_sc_hd__and2_1
XFILLER_0_84_41 VPWR VGND VPWR VGND sky130_ef_sc_hd__decap_12
X_3276_ tree_instances\[0\].u_tree.pipeline_frame_id\[0\]\[3\] _0925_ _0002_ VGND
+ VGND VPWR VPWR _0926_ sky130_fd_sc_hd__mux2_1
X_2227_ _1600_ _1603_ VGND VGND VPWR VPWR _1604_ sky130_fd_sc_hd__nor2_1
XFILLER_0_84_85 VPWR VGND VPWR VGND sky130_ef_sc_hd__decap_12
XFILLER_0_23_3 VGND VGND VPWR VPWR sky130_fd_sc_hd__decap_8
XPHY_EDGE_ROW_24_Right_24 VGND VGND VPWR VPWR sky130_fd_sc_hd__decap_3
XFILLER_0_88_491 VGND VGND VPWR VPWR sky130_fd_sc_hd__fill_1
XFILLER_0_48_399 VGND VGND VPWR VPWR sky130_fd_sc_hd__fill_2
XANTENNA__4021__S _1889_ VGND VGND VPWR VPWR sky130_fd_sc_hd__diode_2
XFILLER_0_31_255 VGND VGND VPWR VPWR sky130_fd_sc_hd__fill_1
XFILLER_0_31_277 VGND VGND VPWR VPWR sky130_fd_sc_hd__decap_3
XPHY_EDGE_ROW_33_Right_33 VGND VGND VPWR VPWR sky130_fd_sc_hd__decap_3
XFILLER_0_31_288 VGND VGND VPWR VPWR sky130_fd_sc_hd__fill_1
XANTENNA__4873__RESET_B net10 VGND VGND VPWR VPWR sky130_fd_sc_hd__diode_2
XPHY_EDGE_ROW_42_Right_42 VGND VGND VPWR VPWR sky130_fd_sc_hd__decap_3
XFILLER_0_58_119 VPWR VGND VPWR VGND sky130_ef_sc_hd__decap_12
XANTENNA__4802__RESET_B tree_instances\[0\].u_tree.rst_n VGND VGND VPWR VPWR sky130_fd_sc_hd__diode_2
XTAP_TAPCELL_ROW_55_762 VGND VPWR sky130_fd_sc_hd__tapvpwrvgnd_1
XTAP_TAPCELL_ROW_27_475 VGND VPWR sky130_fd_sc_hd__tapvpwrvgnd_1
XFILLER_0_66_174 VGND VGND VPWR VPWR sky130_fd_sc_hd__fill_1
XFILLER_0_81_133 VGND VGND VPWR VPWR sky130_fd_sc_hd__fill_2
XFILLER_0_81_166 VGND VGND VPWR VPWR sky130_fd_sc_hd__fill_2
XFILLER_0_35_561 VPWR VGND VPWR VGND sky130_ef_sc_hd__decap_12
XPHY_EDGE_ROW_51_Right_51 VGND VGND VPWR VPWR sky130_fd_sc_hd__decap_3
XFILLER_0_22_277 VGND VGND VPWR VPWR sky130_fd_sc_hd__decap_4
X_3130_ tree_instances\[3\].u_tree.frame_id_out\[4\] VGND VGND VPWR VPWR _0802_ sky130_fd_sc_hd__inv_2
XFILLER_0_89_222 VGND VGND VPWR VPWR sky130_fd_sc_hd__fill_2
XPHY_EDGE_ROW_60_Right_60 VGND VGND VPWR VPWR sky130_fd_sc_hd__decap_3
X_3061_ _0650_ VGND VGND VPWR VPWR _0733_ sky130_fd_sc_hd__buf_4
XFILLER_0_89_233 VGND VGND VPWR VPWR sky130_fd_sc_hd__fill_2
XFILLER_0_77_417 VPWR VGND VPWR VGND sky130_ef_sc_hd__decap_12
XANTENNA__4543__RESET_B net11 VGND VGND VPWR VPWR sky130_fd_sc_hd__diode_2
X_3963_ _1342_ VGND VGND VPWR VPWR _0408_ sky130_fd_sc_hd__clkbuf_1
X_3894_ _1299_ VGND VGND VPWR VPWR _0382_ sky130_fd_sc_hd__clkbuf_1
X_2914_ _0613_ _1831_ VGND VGND VPWR VPWR _0614_ sky130_fd_sc_hd__or2_1
XFILLER_0_45_314 VGND VGND VPWR VPWR sky130_fd_sc_hd__fill_2
X_2845_ _2147_ VGND VGND VPWR VPWR _2148_ sky130_fd_sc_hd__clkbuf_1
XFILLER_0_5_444 VGND VGND VPWR VPWR sky130_fd_sc_hd__decap_4
XFILLER_0_79_41 VGND VGND VPWR VPWR sky130_fd_sc_hd__decap_8
X_2776_ _1651_ VGND VGND VPWR VPWR _2084_ sky130_fd_sc_hd__clkbuf_1
X_4515_ clknet_leaf_61_clk _0246_ tree_instances\[0\].u_tree.rst_n VGND VGND VPWR
+ VPWR tree_instances\[5\].u_tree.frame_id_out\[1\] sky130_fd_sc_hd__dfrtp_1
XFILLER_0_53_391 VGND VGND VPWR VPWR sky130_fd_sc_hd__fill_1
XFILLER_0_79_96 VPWR VGND VPWR VGND sky130_ef_sc_hd__decap_12
XFILLER_0_13_266 VGND VGND VPWR VPWR sky130_fd_sc_hd__fill_2
XFILLER_0_13_244 VGND VGND VPWR VPWR sky130_fd_sc_hd__fill_2
XTAP_TAPCELL_ROW_92_1127 VGND VPWR sky130_fd_sc_hd__tapvpwrvgnd_1
X_4446_ clknet_leaf_67_clk _0078_ net9 VGND VGND VPWR VPWR tree_instances\[7\].u_tree.tree_state\[3\]
+ sky130_fd_sc_hd__dfrtp_4
X_4377_ clknet_leaf_33_clk _0044_ net13 VGND VGND VPWR VPWR tree_instances\[0\].u_tree.tree_state\[3\]
+ sky130_fd_sc_hd__dfrtp_1
XFILLER_0_95_51 VGND VGND VPWR VPWR sky130_fd_sc_hd__decap_4
X_3328_ tree_instances\[1\].u_tree.frame_id_out\[2\] tree_instances\[1\].u_tree.pipeline_frame_id\[0\]\[2\]
+ tree_instances\[1\].u_tree.tree_state\[3\] VGND VGND VPWR VPWR _0953_ sky130_fd_sc_hd__mux2_1
XFILLER_0_0_193 VGND VGND VPWR VPWR sky130_fd_sc_hd__decap_3
X_3259_ _2133_ _0912_ VGND VGND VPWR VPWR _0917_ sky130_fd_sc_hd__and2_1
XTAP_TAPCELL_ROW_69_898 VGND VPWR sky130_fd_sc_hd__tapvpwrvgnd_1
XFILLER_0_95_214 VGND VGND VPWR VPWR sky130_fd_sc_hd__decap_4
XFILLER_0_83_409 VGND VGND VPWR VPWR sky130_fd_sc_hd__fill_1
XTAP_TAPCELL_ROW_24_445 VGND VPWR sky130_fd_sc_hd__tapvpwrvgnd_1
XFILLER_0_48_130 VGND VGND VPWR VPWR sky130_fd_sc_hd__fill_1
XTAP_TAPCELL_ROW_52_732 VGND VPWR sky130_fd_sc_hd__tapvpwrvgnd_1
XFILLER_0_91_464 VPWR VGND VPWR VGND sky130_ef_sc_hd__decap_12
XFILLER_0_8_260 VPWR VGND VPWR VGND sky130_ef_sc_hd__decap_12
XFILLER_0_63_166 VGND VGND VPWR VPWR sky130_fd_sc_hd__fill_2
XFILLER_0_17_561 VPWR VGND VPWR VGND sky130_ef_sc_hd__decap_12
XFILLER_0_32_531 VGND VGND VPWR VPWR sky130_fd_sc_hd__fill_1
XANTENNA__3194__A1 _0646_ VGND VGND VPWR VPWR sky130_fd_sc_hd__diode_2
XANTENNA__3194__B2 _0695_ VGND VGND VPWR VPWR sky130_fd_sc_hd__diode_2
XFILLER_0_39_174 VGND VGND VPWR VPWR sky130_fd_sc_hd__fill_2
XFILLER_0_54_100 VGND VGND VPWR VPWR sky130_fd_sc_hd__fill_2
X_2630_ tree_instances\[18\].u_tree.pipeline_current_node\[0\]\[1\] tree_instances\[18\].u_tree.pipeline_current_node\[0\]\[0\]
+ VGND VGND VPWR VPWR _1956_ sky130_fd_sc_hd__or2_1
XFILLER_0_40_57 VGND VGND VPWR VPWR sky130_fd_sc_hd__decap_8
XFILLER_0_40_68 VGND VGND VPWR VPWR sky130_fd_sc_hd__fill_2
X_2561_ tree_instances\[20\].u_tree.pipeline_current_node\[0\]\[1\] tree_instances\[20\].u_tree.pipeline_current_node\[0\]\[0\]
+ VGND VGND VPWR VPWR _1899_ sky130_fd_sc_hd__or2_1
XFILLER_0_23_553 VGND VGND VPWR VPWR sky130_fd_sc_hd__decap_6
XFILLER_0_50_361 VGND VGND VPWR VPWR sky130_fd_sc_hd__decap_3
X_4300_ tree_instances\[20\].u_tree.pipeline_current_node\[0\]\[8\] _1523_ VGND VGND
+ VPWR VPWR _1533_ sky130_fd_sc_hd__and2_1
X_2492_ _1837_ VGND VGND VPWR VPWR _1838_ sky130_fd_sc_hd__clkbuf_1
XFILLER_0_49_55 VGND VGND VPWR VPWR sky130_fd_sc_hd__fill_1
X_4231_ tree_instances\[18\].u_tree.frame_id_out\[4\] tree_instances\[18\].u_tree.pipeline_frame_id\[0\]\[4\]
+ tree_instances\[18\].u_tree.tree_state\[3\] VGND VGND VPWR VPWR _1497_ sky130_fd_sc_hd__mux2_1
XFILLER_0_49_88 VGND VGND VPWR VPWR sky130_fd_sc_hd__fill_2
XANTENNA__4795__RESET_B net10 VGND VGND VPWR VPWR sky130_fd_sc_hd__diode_2
X_4162_ tree_instances\[17\].u_tree.pipeline_current_node\[0\]\[6\] VGND VGND VPWR
+ VPWR _1461_ sky130_fd_sc_hd__clkbuf_1
XFILLER_0_4_57 VPWR VGND VPWR VGND sky130_ef_sc_hd__decap_12
XANTENNA__4724__RESET_B net10 VGND VGND VPWR VPWR sky130_fd_sc_hd__diode_2
X_3113_ _0684_ tree_instances\[4\].u_tree.frame_id_out\[1\] tree_instances\[4\].u_tree.frame_id_out\[3\]
+ _0689_ VGND VGND VPWR VPWR _0785_ sky130_fd_sc_hd__a2bb2o_1
X_4093_ _1409_ VGND VGND VPWR VPWR _0471_ sky130_fd_sc_hd__clkbuf_1
X_3044_ _0661_ tree_instances\[14\].u_tree.frame_id_out\[4\] VGND VGND VPWR VPWR _0716_
+ sky130_fd_sc_hd__xnor2_1
XFILLER_0_77_203 VGND VGND VPWR VPWR sky130_fd_sc_hd__fill_2
XTAP_TAPCELL_ROW_66_868 VGND VPWR sky130_fd_sc_hd__tapvpwrvgnd_1
XFILLER_0_77_225 VGND VGND VPWR VPWR sky130_fd_sc_hd__decap_8
XFILLER_0_92_206 VGND VGND VPWR VPWR sky130_fd_sc_hd__decap_4
X_3946_ _1862_ _1332_ VGND VGND VPWR VPWR _1334_ sky130_fd_sc_hd__and2_1
XFILLER_0_45_111 VGND VGND VPWR VPWR sky130_fd_sc_hd__fill_1
XFILLER_0_73_431 VGND VGND VPWR VPWR sky130_fd_sc_hd__decap_4
XTAP_TAPCELL_ROW_21_415 VGND VPWR sky130_fd_sc_hd__tapvpwrvgnd_1
XFILLER_0_90_3 VGND VGND VPWR VPWR sky130_fd_sc_hd__decap_8
X_3877_ _1286_ VGND VGND VPWR VPWR _1287_ sky130_fd_sc_hd__clkbuf_1
XFILLER_0_73_464 VPWR VGND VPWR VGND sky130_ef_sc_hd__decap_12
XFILLER_0_45_155 VGND VGND VPWR VPWR sky130_fd_sc_hd__fill_1
X_2828_ _2127_ VGND VGND VPWR VPWR _2131_ sky130_fd_sc_hd__clkbuf_1
XFILLER_0_14_531 VGND VGND VPWR VPWR sky130_fd_sc_hd__fill_1
X_2759_ tree_instances\[12\].u_tree.prediction_valid _1579_ VGND VGND VPWR VPWR _2069_
+ sky130_fd_sc_hd__and2b_1
X_4429_ clknet_leaf_55_clk _0175_ net9 VGND VGND VPWR VPWR tree_instances\[2\].u_tree.pipeline_current_node\[0\]\[7\]
+ sky130_fd_sc_hd__dfrtp_1
XANTENNA__4465__RESET_B tree_instances\[0\].u_tree.rst_n VGND VGND VPWR VPWR sky130_fd_sc_hd__diode_2
XFILLER_0_96_501 VGND VGND VPWR VPWR sky130_fd_sc_hd__decap_3
XANTENNA__3100__A1 _0697_ VGND VGND VPWR VPWR sky130_fd_sc_hd__diode_2
XFILLER_0_96_545 VPWR VGND VPWR VGND sky130_ef_sc_hd__decap_12
XTAP_TAPCELL_ROW_37_581 VGND VPWR sky130_fd_sc_hd__tapvpwrvgnd_1
XFILLER_0_36_100 VGND VGND VPWR VPWR sky130_fd_sc_hd__decap_6
XFILLER_0_91_261 VPWR VGND VPWR VGND sky130_ef_sc_hd__decap_12
XFILLER_0_64_475 VGND VGND VPWR VPWR sky130_fd_sc_hd__fill_1
XFILLER_0_10_27 VGND VGND VPWR VPWR sky130_fd_sc_hd__fill_1
XFILLER_0_24_339 VGND VGND VPWR VPWR sky130_fd_sc_hd__fill_1
XFILLER_0_36_188 VGND VGND VPWR VPWR sky130_fd_sc_hd__fill_1
XFILLER_0_51_125 VPWR VGND VPWR VGND sky130_ef_sc_hd__decap_12
XFILLER_0_51_169 VPWR VGND VPWR VGND sky130_ef_sc_hd__decap_12
XTAP_TAPCELL_ROW_9_295 VGND VPWR sky130_fd_sc_hd__tapvpwrvgnd_1
XFILLER_0_19_69 VPWR VGND VPWR VGND sky130_ef_sc_hd__decap_12
XFILLER_0_87_501 VGND VGND VPWR VPWR sky130_fd_sc_hd__decap_3
XFILLER_0_35_57 VPWR VGND VPWR VGND sky130_ef_sc_hd__decap_12
XTAP_TAPCELL_ROW_63_838 VGND VPWR sky130_fd_sc_hd__tapvpwrvgnd_1
XFILLER_0_59_225 VPWR VGND VPWR VGND sky130_ef_sc_hd__decap_12
XPHY_EDGE_ROW_72_Left_169 VGND VGND VPWR VPWR sky130_fd_sc_hd__decap_3
XFILLER_0_27_111 VGND VGND VPWR VPWR sky130_fd_sc_hd__fill_1
X_4780_ clknet_leaf_51_clk _0468_ net13 VGND VGND VPWR VPWR tree_instances\[16\].u_tree.pipeline_current_node\[0\]\[6\]
+ sky130_fd_sc_hd__dfrtp_1
X_3800_ tree_instances\[10\].u_tree.pipeline_frame_id\[0\]\[1\] _1124_ _0004_ VGND
+ VGND VPWR VPWR _1243_ sky130_fd_sc_hd__mux2_1
XFILLER_0_7_517 VPWR VGND VPWR VGND sky130_ef_sc_hd__decap_12
X_3731_ _1202_ VGND VGND VPWR VPWR _1205_ sky130_fd_sc_hd__clkbuf_1
XFILLER_0_27_166 VGND VGND VPWR VPWR sky130_fd_sc_hd__fill_2
Xclkload10 clknet_leaf_69_clk VGND VGND VPWR VPWR clkload10/Y sky130_fd_sc_hd__inv_6
X_3662_ _0674_ VGND VGND VPWR VPWR _1165_ sky130_fd_sc_hd__clkbuf_4
X_2613_ _1940_ VGND VGND VPWR VPWR _1941_ sky130_fd_sc_hd__clkbuf_1
X_3593_ _1120_ _1096_ VGND VGND VPWR VPWR _1121_ sky130_fd_sc_hd__and2_1
Xclkload32 clknet_leaf_19_clk VGND VGND VPWR VPWR clkload32/Y sky130_fd_sc_hd__clkinvlp_2
Xclkload21 clknet_leaf_9_clk VGND VGND VPWR VPWR clkload21/Y sky130_fd_sc_hd__bufinv_16
XFILLER_0_30_309 VGND VGND VPWR VPWR sky130_fd_sc_hd__fill_2
Xclkload43 clknet_leaf_47_clk VGND VGND VPWR VPWR clkload43/Y sky130_fd_sc_hd__inv_8
XFILLER_0_42_147 VGND VGND VPWR VPWR sky130_fd_sc_hd__fill_1
XANTENNA__3158__A1 _0654_ VGND VGND VPWR VPWR sky130_fd_sc_hd__diode_2
XANTENNA__3158__B2 _0702_ VGND VGND VPWR VPWR sky130_fd_sc_hd__diode_2
Xclkload54 clknet_leaf_29_clk VGND VGND VPWR VPWR clkload54/Y sky130_fd_sc_hd__clkinv_4
X_2544_ tree_instances\[2\].u_tree.pipeline_current_node\[0\]\[5\] tree_instances\[2\].u_tree.pipeline_current_node\[0\]\[4\]
+ VGND VGND VPWR VPWR _1885_ sky130_fd_sc_hd__nor2_1
Xclkload65 clknet_leaf_41_clk VGND VGND VPWR VPWR clkload65/Y sky130_fd_sc_hd__clkinv_1
XPHY_EDGE_ROW_81_Left_178 VGND VGND VPWR VPWR sky130_fd_sc_hd__decap_3
X_2475_ tree_instances\[4\].u_tree.tree_state\[2\] _1808_ _1825_ tree_instances\[4\].u_tree.tree_state\[1\]
+ VGND VGND VPWR VPWR _0072_ sky130_fd_sc_hd__a31o_1
X_4214_ _1488_ VGND VGND VPWR VPWR _0513_ sky130_fd_sc_hd__clkbuf_1
X_4145_ _1447_ _1444_ VGND VGND VPWR VPWR _1448_ sky130_fd_sc_hd__and2_1
XFILLER_0_92_41 VGND VGND VPWR VPWR sky130_fd_sc_hd__fill_1
X_4076_ _2050_ _1399_ VGND VGND VPWR VPWR _1401_ sky130_fd_sc_hd__and2_1
XFILLER_0_78_545 VGND VGND VPWR VPWR sky130_fd_sc_hd__decap_4
X_3027_ _0694_ tree_instances\[6\].u_tree.frame_id_out\[0\] tree_instances\[6\].u_tree.frame_id_out\[4\]
+ _0697_ _0698_ VGND VGND VPWR VPWR _0699_ sky130_fd_sc_hd__a221o_1
XPHY_EDGE_ROW_90_Left_187 VGND VGND VPWR VPWR sky130_fd_sc_hd__decap_3
XFILLER_0_65_206 VPWR VGND VPWR VGND sky130_ef_sc_hd__decap_12
XTAP_TAPCELL_ROW_34_551 VGND VPWR sky130_fd_sc_hd__tapvpwrvgnd_1
XFILLER_0_18_133 VGND VGND VPWR VPWR sky130_fd_sc_hd__decap_6
XFILLER_0_73_272 VGND VGND VPWR VPWR sky130_fd_sc_hd__decap_8
Xclkload4 clknet_leaf_0_clk VGND VGND VPWR VPWR clkload4/Y sky130_fd_sc_hd__clkinvlp_4
XFILLER_0_46_486 VGND VGND VPWR VPWR sky130_fd_sc_hd__fill_1
X_3929_ _1315_ VGND VGND VPWR VPWR _1319_ sky130_fd_sc_hd__clkbuf_1
XFILLER_0_73_294 VGND VGND VPWR VPWR sky130_fd_sc_hd__fill_2
XFILLER_0_21_309 VGND VGND VPWR VPWR sky130_fd_sc_hd__fill_1
XFILLER_0_33_169 VGND VGND VPWR VPWR sky130_fd_sc_hd__decap_8
XTAP_TAPCELL_ROW_6_265 VGND VPWR sky130_fd_sc_hd__tapvpwrvgnd_1
XFILLER_0_88_309 VGND VGND VPWR VPWR sky130_fd_sc_hd__fill_2
XFILLER_0_69_512 VPWR VGND VPWR VGND sky130_ef_sc_hd__decap_12
XFILLER_0_69_545 VGND VGND VPWR VPWR sky130_fd_sc_hd__fill_1
XFILLER_0_69_567 VGND VGND VPWR VPWR sky130_fd_sc_hd__decap_6
XFILLER_0_84_515 VGND VGND VPWR VPWR sky130_fd_sc_hd__fill_2
XTAP_TAPCELL_ROW_60_808 VGND VPWR sky130_fd_sc_hd__tapvpwrvgnd_1
XFILLER_0_56_217 VGND VGND VPWR VPWR sky130_fd_sc_hd__decap_3
XFILLER_0_37_442 VGND VGND VPWR VPWR sky130_fd_sc_hd__fill_2
XFILLER_0_64_261 VGND VGND VPWR VPWR sky130_fd_sc_hd__decap_3
XFILLER_0_21_48 VGND VGND VPWR VPWR sky130_fd_sc_hd__decap_8
XFILLER_0_52_445 VPWR VGND VPWR VGND sky130_ef_sc_hd__decap_12
XFILLER_0_12_309 VGND VGND VPWR VPWR sky130_fd_sc_hd__decap_4
XFILLER_0_24_147 VGND VGND VPWR VPWR sky130_fd_sc_hd__fill_1
XANTENNA__4387__RESET_B net13 VGND VGND VPWR VPWR sky130_fd_sc_hd__diode_2
X_2260_ tree_instances\[0\].u_tree.pipeline_current_node\[0\]\[6\] VGND VGND VPWR
+ VPWR _1635_ sky130_fd_sc_hd__clkbuf_1
XFILLER_0_20_397 VPWR VGND VPWR VGND sky130_ef_sc_hd__decap_12
XFILLER_0_46_23 VGND VGND VPWR VPWR sky130_fd_sc_hd__fill_1
X_2191_ tree_instances\[12\].u_tree.tree_state\[2\] _1558_ _1573_ tree_instances\[12\].u_tree.tree_state\[1\]
+ VGND VGND VPWR VPWR _0049_ sky130_fd_sc_hd__a31o_1
XFILLER_0_46_45 VGND VGND VPWR VPWR sky130_fd_sc_hd__fill_1
XFILLER_0_46_89 VPWR VGND VPWR VGND sky130_ef_sc_hd__decap_12
XFILLER_0_62_11 VGND VGND VPWR VPWR sky130_fd_sc_hd__decap_3
XTAP_TAPCELL_ROW_48_687 VGND VPWR sky130_fd_sc_hd__tapvpwrvgnd_1
XTAP_TAPCELL_ROW_86_1070 VGND VPWR sky130_fd_sc_hd__tapvpwrvgnd_1
XFILLER_0_1_69 VGND VGND VPWR VPWR sky130_fd_sc_hd__decap_8
XFILLER_0_75_548 VGND VGND VPWR VPWR sky130_fd_sc_hd__fill_2
X_4832_ clknet_leaf_46_clk _0514_ net13 VGND VGND VPWR VPWR tree_instances\[18\].u_tree.pipeline_frame_id\[0\]\[1\]
+ sky130_fd_sc_hd__dfrtp_1
XFILLER_0_90_507 VPWR VGND VPWR VGND sky130_ef_sc_hd__decap_12
XTAP_TAPCELL_ROW_31_521 VGND VPWR sky130_fd_sc_hd__tapvpwrvgnd_1
X_4763_ clknet_leaf_41_clk _0460_ net10 VGND VGND VPWR VPWR tree_instances\[15\].u_tree.ready_for_next
+ sky130_fd_sc_hd__dfstp_1
X_4694_ clknet_leaf_19_clk _0088_ net11 VGND VGND VPWR VPWR tree_instances\[12\].u_tree.prediction_valid
+ sky130_fd_sc_hd__dfrtp_1
X_3714_ _1194_ VGND VGND VPWR VPWR _0307_ sky130_fd_sc_hd__clkbuf_1
XFILLER_0_15_136 VPWR VGND VPWR VGND sky130_ef_sc_hd__decap_12
XANTENNA__4841__SET_B net10 VGND VGND VPWR VPWR sky130_fd_sc_hd__diode_2
XFILLER_0_55_294 VGND VGND VPWR VPWR sky130_fd_sc_hd__decap_4
XFILLER_0_70_253 VPWR VGND VPWR VGND sky130_ef_sc_hd__decap_12
XFILLER_0_43_456 VPWR VGND VPWR VGND sky130_ef_sc_hd__decap_12
XANTENNA__3238__B _0000_ VGND VGND VPWR VPWR sky130_fd_sc_hd__diode_2
X_3645_ _1154_ _1139_ VGND VGND VPWR VPWR _1155_ sky130_fd_sc_hd__and2_1
XFILLER_0_3_553 VGND VGND VPWR VPWR sky130_fd_sc_hd__decap_6
X_3576_ _1107_ VGND VGND VPWR VPWR _1108_ sky130_fd_sc_hd__clkbuf_1
XFILLER_0_30_139 VGND VGND VPWR VPWR sky130_fd_sc_hd__fill_1
XFILLER_0_87_85 VGND VGND VPWR VPWR sky130_fd_sc_hd__fill_1
X_2527_ _1870_ VGND VGND VPWR VPWR _0039_ sky130_fd_sc_hd__clkbuf_1
X_2458_ tree_instances\[4\].u_tree.pipeline_current_node\[0\]\[6\] VGND VGND VPWR
+ VPWR _1809_ sky130_fd_sc_hd__inv_2
XFILLER_0_53_3 VGND VGND VPWR VPWR sky130_fd_sc_hd__decap_3
XPHY_EDGE_ROW_89_Right_89 VGND VGND VPWR VPWR sky130_fd_sc_hd__decap_3
X_2389_ _1748_ VGND VGND VPWR VPWR _1749_ sky130_fd_sc_hd__clkbuf_1
XTAP_TAPCELL_ROW_3_235 VGND VPWR sky130_fd_sc_hd__tapvpwrvgnd_1
X_4128_ _1423_ VGND VGND VPWR VPWR _1434_ sky130_fd_sc_hd__clkbuf_1
X_4059_ _1391_ VGND VGND VPWR VPWR _0455_ sky130_fd_sc_hd__clkbuf_1
XFILLER_0_93_389 VGND VGND VPWR VPWR sky130_fd_sc_hd__decap_3
XFILLER_0_53_209 VPWR VGND VPWR VGND sky130_ef_sc_hd__decap_12
XANTENNA__4827__RESET_B net10 VGND VGND VPWR VPWR sky130_fd_sc_hd__diode_2
XFILLER_0_61_286 VGND VGND VPWR VPWR sky130_fd_sc_hd__fill_2
XFILLER_0_34_489 VPWR VGND VPWR VGND sky130_ef_sc_hd__decap_12
XANTENNA__4480__RESET_B tree_instances\[0\].u_tree.rst_n VGND VGND VPWR VPWR sky130_fd_sc_hd__diode_2
XANTENNA__3164__A _0726_ VGND VGND VPWR VPWR sky130_fd_sc_hd__diode_2
XFILLER_0_16_26 VGND VGND VPWR VPWR sky130_fd_sc_hd__fill_2
XFILLER_0_69_397 VGND VGND VPWR VPWR sky130_fd_sc_hd__decap_8
XTAP_TAPCELL_ROW_45_657 VGND VPWR sky130_fd_sc_hd__tapvpwrvgnd_1
XFILLER_0_84_389 VPWR VGND VPWR VGND sky130_ef_sc_hd__decap_12
XFILLER_0_72_529 VGND VGND VPWR VPWR sky130_fd_sc_hd__decap_3
XFILLER_0_32_58 VPWR VGND VPWR VGND sky130_ef_sc_hd__decap_12
XFILLER_0_25_423 VGND VGND VPWR VPWR sky130_fd_sc_hd__fill_1
XANTENNA__4568__RESET_B tree_instances\[0\].u_tree.rst_n VGND VGND VPWR VPWR sky130_fd_sc_hd__diode_2
XFILLER_0_80_573 VGND VGND VPWR VPWR sky130_fd_sc_hd__fill_1
XFILLER_0_0_501 VGND VGND VPWR VPWR sky130_fd_sc_hd__decap_3
X_3430_ tree_instances\[3\].u_tree.frame_id_out\[2\] tree_instances\[3\].u_tree.pipeline_frame_id\[0\]\[2\]
+ _1872_ VGND VGND VPWR VPWR _1013_ sky130_fd_sc_hd__mux2_1
XFILLER_0_40_437 VPWR VGND VPWR VGND sky130_ef_sc_hd__decap_12
XFILLER_0_0_545 VPWR VGND VPWR VGND sky130_ef_sc_hd__decap_12
X_3361_ _0975_ VGND VGND VPWR VPWR _0976_ sky130_fd_sc_hd__clkbuf_1
XANTENNA__3533__A1 _0673_ VGND VGND VPWR VPWR sky130_fd_sc_hd__diode_2
X_2312_ tree_instances\[7\].u_tree.pipeline_current_node\[0\]\[5\] VGND VGND VPWR
+ VPWR _1680_ sky130_fd_sc_hd__clkbuf_1
X_3292_ tree_instances\[17\].u_tree.tree_state\[0\] _1828_ VGND VGND VPWR VPWR _0934_
+ sky130_fd_sc_hd__nand2_1
X_2243_ _1617_ _1618_ VGND VGND VPWR VPWR _1619_ sky130_fd_sc_hd__nor2_1
X_2174_ _1556_ VGND VGND VPWR VPWR _1557_ sky130_fd_sc_hd__inv_2
XFILLER_0_73_21 VGND VGND VPWR VPWR sky130_fd_sc_hd__fill_2
XTAP_TAPCELL_ROW_0_205 VGND VPWR sky130_fd_sc_hd__tapvpwrvgnd_1
XFILLER_0_75_356 VPWR VGND VPWR VGND sky130_ef_sc_hd__decap_12
XTAP_TAPCELL_ROW_16_370 VGND VPWR sky130_fd_sc_hd__tapvpwrvgnd_1
X_4815_ clknet_leaf_47_clk _0502_ net10 VGND VGND VPWR VPWR tree_instances\[17\].u_tree.ready_for_next
+ sky130_fd_sc_hd__dfstp_1
XFILLER_0_90_337 VPWR VGND VPWR VGND sky130_ef_sc_hd__decap_12
XFILLER_0_7_133 VGND VGND VPWR VPWR sky130_fd_sc_hd__decap_4
X_4746_ clknet_leaf_41_clk _0443_ net10 VGND VGND VPWR VPWR tree_instances\[15\].u_tree.pipeline_current_node\[0\]\[2\]
+ sky130_fd_sc_hd__dfrtp_1
XFILLER_0_7_188 VGND VGND VPWR VPWR sky130_fd_sc_hd__fill_1
X_4677_ clknet_leaf_17_clk _0381_ net11 VGND VGND VPWR VPWR tree_instances\[12\].u_tree.pipeline_current_node\[0\]\[3\]
+ sky130_fd_sc_hd__dfrtp_1
XFILLER_0_71_573 VGND VGND VPWR VPWR sky130_fd_sc_hd__fill_1
XTAP_TAPCELL_ROW_95_1158 VGND VPWR sky130_fd_sc_hd__tapvpwrvgnd_1
X_3628_ tree_instances\[7\].u_tree.pipeline_current_node\[0\]\[1\] VGND VGND VPWR
+ VPWR _1141_ sky130_fd_sc_hd__clkbuf_1
XFILLER_0_3_361 VPWR VGND VPWR VGND sky130_ef_sc_hd__decap_12
X_3559_ _1093_ VGND VGND VPWR VPWR _1094_ sky130_fd_sc_hd__clkbuf_1
XANTENNA__4019__S _1889_ VGND VGND VPWR VPWR sky130_fd_sc_hd__diode_2
XFILLER_0_66_334 VGND VGND VPWR VPWR sky130_fd_sc_hd__decap_6
XFILLER_0_39_559 VGND VGND VPWR VPWR sky130_fd_sc_hd__fill_1
XTAP_TAPCELL_ROW_42_627 VGND VPWR sky130_fd_sc_hd__tapvpwrvgnd_1
XFILLER_0_81_337 VGND VGND VPWR VPWR sky130_fd_sc_hd__fill_2
XFILLER_0_19_261 VPWR VGND VPWR VGND sky130_ef_sc_hd__decap_12
XANTENNA__3159__A _0651_ VGND VGND VPWR VPWR sky130_fd_sc_hd__diode_2
XANTENNA__4661__RESET_B tree_instances\[0\].u_tree.rst_n VGND VGND VPWR VPWR sky130_fd_sc_hd__diode_2
XANTENNA__2998__A _0673_ VGND VGND VPWR VPWR sky130_fd_sc_hd__diode_2
XFILLER_0_62_573 VGND VGND VPWR VPWR sky130_fd_sc_hd__fill_1
XFILLER_0_34_253 VGND VGND VPWR VPWR sky130_fd_sc_hd__fill_1
XFILLER_0_34_297 VGND VGND VPWR VPWR sky130_fd_sc_hd__decap_8
XFILLER_0_27_69 VGND VGND VPWR VPWR sky130_fd_sc_hd__fill_1
XFILLER_0_89_415 VGND VGND VPWR VPWR sky130_fd_sc_hd__fill_1
XTAP_TAPCELL_ROW_58_793 VGND VPWR sky130_fd_sc_hd__tapvpwrvgnd_1
XANTENNA_clkload2_A clknet_3_4__leaf_clk VGND VGND VPWR VPWR sky130_fd_sc_hd__diode_2
XFILLER_0_76_109 VGND VGND VPWR VPWR sky130_fd_sc_hd__decap_6
XTAP_TAPCELL_ROW_83_1040 VGND VPWR sky130_fd_sc_hd__tapvpwrvgnd_1
X_2930_ _0623_ _1771_ VGND VGND VPWR VPWR _0624_ sky130_fd_sc_hd__or2_1
XFILLER_0_43_57 VGND VGND VPWR VPWR sky130_fd_sc_hd__decap_4
XANTENNA__4749__RESET_B net10 VGND VGND VPWR VPWR sky130_fd_sc_hd__diode_2
X_2861_ tree_instances\[1\].u_tree.pipeline_current_node\[0\]\[7\] VGND VGND VPWR
+ VPWR _2163_ sky130_fd_sc_hd__clkbuf_1
XFILLER_0_84_197 VGND VGND VPWR VPWR sky130_fd_sc_hd__decap_6
XFILLER_0_72_326 VGND VGND VPWR VPWR sky130_fd_sc_hd__fill_2
XTAP_TAPCELL_ROW_13_340 VGND VPWR sky130_fd_sc_hd__tapvpwrvgnd_1
X_4600_ clknet_leaf_0_clk _0315_ net9 VGND VGND VPWR VPWR tree_instances\[9\].u_tree.pipeline_current_node\[0\]\[1\]
+ sky130_fd_sc_hd__dfrtp_1
X_2792_ _1814_ VGND VGND VPWR VPWR _2097_ sky130_fd_sc_hd__clkbuf_1
XFILLER_0_53_540 VGND VGND VPWR VPWR sky130_fd_sc_hd__decap_8
X_4531_ clknet_leaf_20_clk _0261_ net11 VGND VGND VPWR VPWR tree_instances\[6\].u_tree.pipeline_current_node\[0\]\[8\]
+ sky130_fd_sc_hd__dfrtp_1
XANTENNA__3754__A1 _1162_ VGND VGND VPWR VPWR sky130_fd_sc_hd__diode_2
XFILLER_0_13_415 VPWR VGND VPWR VGND sky130_ef_sc_hd__decap_12
XFILLER_0_53_573 VGND VGND VPWR VPWR sky130_fd_sc_hd__fill_1
XFILLER_0_13_459 VGND VGND VPWR VPWR sky130_fd_sc_hd__fill_2
X_4462_ clknet_leaf_63_clk _0203_ net9 VGND VGND VPWR VPWR tree_instances\[3\].u_tree.frame_id_out\[0\]
+ sky130_fd_sc_hd__dfrtp_1
XANTENNA__4331__RESET_B net9 VGND VGND VPWR VPWR sky130_fd_sc_hd__diode_2
XFILLER_0_40_223 VGND VGND VPWR VPWR sky130_fd_sc_hd__decap_3
X_3413_ _1004_ VGND VGND VPWR VPWR _0196_ sky130_fd_sc_hd__clkbuf_1
X_4393_ clknet_leaf_30_clk _0141_ net11 VGND VGND VPWR VPWR tree_instances\[0\].u_tree.frame_id_out\[1\]
+ sky130_fd_sc_hd__dfrtp_1
X_3344_ _0962_ VGND VGND VPWR VPWR _0963_ sky130_fd_sc_hd__clkbuf_1
X_3275_ _0678_ VGND VGND VPWR VPWR _0925_ sky130_fd_sc_hd__clkbuf_4
XFILLER_0_84_53 VPWR VGND VPWR VGND sky130_ef_sc_hd__decap_12
X_2226_ _1602_ VGND VGND VPWR VPWR _1603_ sky130_fd_sc_hd__clkbuf_1
XFILLER_0_84_97 VPWR VGND VPWR VGND sky130_ef_sc_hd__decap_12
XFILLER_0_16_3 VGND VGND VPWR VPWR sky130_fd_sc_hd__decap_3
XFILLER_0_8_475 VGND VGND VPWR VPWR sky130_fd_sc_hd__fill_1
XFILLER_0_16_231 VPWR VGND VPWR VGND sky130_ef_sc_hd__decap_12
X_4729_ clknet_leaf_39_clk _0427_ net10 VGND VGND VPWR VPWR tree_instances\[14\].u_tree.pipeline_current_node\[0\]\[7\]
+ sky130_fd_sc_hd__dfrtp_1
XFILLER_0_44_573 VGND VGND VPWR VPWR sky130_fd_sc_hd__fill_1
XANTENNA__4302__S _0026_ VGND VGND VPWR VPWR sky130_fd_sc_hd__diode_2
XANTENNA__4170__A1 _0664_ VGND VGND VPWR VPWR sky130_fd_sc_hd__diode_2
XFILLER_0_86_418 VGND VGND VPWR VPWR sky130_fd_sc_hd__fill_2
XTAP_TAPCELL_ROW_27_476 VGND VPWR sky130_fd_sc_hd__tapvpwrvgnd_1
XTAP_TAPCELL_ROW_55_763 VGND VPWR sky130_fd_sc_hd__tapvpwrvgnd_1
XFILLER_0_13_16 VGND VGND VPWR VPWR sky130_fd_sc_hd__fill_2
XANTENNA__4842__RESET_B net13 VGND VGND VPWR VPWR sky130_fd_sc_hd__diode_2
XFILLER_0_66_197 VGND VGND VPWR VPWR sky130_fd_sc_hd__fill_2
XFILLER_0_35_540 VGND VGND VPWR VPWR sky130_fd_sc_hd__fill_2
XFILLER_0_54_359 VGND VGND VPWR VPWR sky130_fd_sc_hd__fill_2
XTAP_TAPCELL_ROW_10_310 VGND VPWR sky130_fd_sc_hd__tapvpwrvgnd_1
XFILLER_0_35_573 VGND VGND VPWR VPWR sky130_fd_sc_hd__fill_1
XFILLER_0_10_407 VPWR VGND VPWR VGND sky130_ef_sc_hd__decap_12
XFILLER_0_50_554 VPWR VGND VPWR VGND sky130_ef_sc_hd__decap_12
XFILLER_0_10_429 VGND VGND VPWR VPWR sky130_fd_sc_hd__fill_1
X_3060_ _0651_ _0730_ tree_instances\[17\].u_tree.frame_id_out\[3\] _0702_ _0731_
+ VGND VGND VPWR VPWR _0732_ sky130_fd_sc_hd__a221o_1
XFILLER_0_89_267 VGND VGND VPWR VPWR sky130_fd_sc_hd__fill_2
XFILLER_0_77_429 VPWR VGND VPWR VGND sky130_ef_sc_hd__decap_12
XFILLER_0_49_109 VGND VGND VPWR VPWR sky130_fd_sc_hd__decap_3
XFILLER_0_54_89 VGND VGND VPWR VPWR sky130_fd_sc_hd__fill_2
XANTENNA__4583__RESET_B net11 VGND VGND VPWR VPWR sky130_fd_sc_hd__diode_2
XFILLER_0_9_217 VGND VGND VPWR VPWR sky130_fd_sc_hd__decap_6
XFILLER_0_18_507 VPWR VGND VPWR VGND sky130_ef_sc_hd__decap_12
X_3962_ tree_instances\[13\].u_tree.pipeline_frame_id\[0\]\[0\] _1162_ _0010_ VGND
+ VGND VPWR VPWR _1342_ sky130_fd_sc_hd__mux2_1
X_3893_ _2023_ _1294_ VGND VGND VPWR VPWR _1299_ sky130_fd_sc_hd__and2_1
X_2913_ tree_instances\[0\].u_tree.tree_state\[0\] VGND VGND VPWR VPWR _0613_ sky130_fd_sc_hd__inv_2
XFILLER_0_45_337 VGND VGND VPWR VPWR sky130_fd_sc_hd__fill_2
X_2844_ _1902_ VGND VGND VPWR VPWR _2147_ sky130_fd_sc_hd__clkbuf_1
XANTENNA__4512__RESET_B tree_instances\[0\].u_tree.rst_n VGND VGND VPWR VPWR sky130_fd_sc_hd__diode_2
XFILLER_0_79_20 VGND VGND VPWR VPWR sky130_fd_sc_hd__fill_1
XFILLER_0_72_189 VGND VGND VPWR VPWR sky130_fd_sc_hd__fill_2
XFILLER_0_60_329 VGND VGND VPWR VPWR sky130_fd_sc_hd__fill_2
X_2775_ _2073_ VGND VGND VPWR VPWR _2083_ sky130_fd_sc_hd__clkbuf_1
X_4514_ clknet_leaf_59_clk _0245_ net13 VGND VGND VPWR VPWR tree_instances\[5\].u_tree.frame_id_out\[0\]
+ sky130_fd_sc_hd__dfrtp_1
XTAP_TAPCELL_ROW_92_1128 VGND VPWR sky130_fd_sc_hd__tapvpwrvgnd_1
XFILLER_0_13_278 VGND VGND VPWR VPWR sky130_fd_sc_hd__fill_2
X_4445_ clknet_leaf_67_clk _0038_ net9 VGND VGND VPWR VPWR tree_instances\[7\].u_tree.tree_state\[2\]
+ sky130_fd_sc_hd__dfrtp_1
X_4376_ clknet_leaf_33_clk _0002_ net13 VGND VGND VPWR VPWR tree_instances\[0\].u_tree.tree_state\[2\]
+ sky130_fd_sc_hd__dfrtp_1
X_3327_ _0952_ VGND VGND VPWR VPWR _0162_ sky130_fd_sc_hd__clkbuf_1
X_3258_ _0916_ VGND VGND VPWR VPWR _0129_ sky130_fd_sc_hd__clkbuf_1
XTAP_TAPCELL_ROW_69_899 VGND VPWR sky130_fd_sc_hd__tapvpwrvgnd_1
X_3189_ _0657_ _0859_ _0853_ _0661_ _0860_ VGND VGND VPWR VPWR _0861_ sky130_fd_sc_hd__o221a_1
X_2209_ tree_instances\[9\].u_tree.pipeline_current_node\[0\]\[5\] VGND VGND VPWR
+ VPWR _1589_ sky130_fd_sc_hd__clkbuf_1
XANTENNA_clkbuf_leaf_54_clk_A clknet_3_4__leaf_clk VGND VGND VPWR VPWR sky130_fd_sc_hd__diode_2
XTAP_TAPCELL_ROW_52_733 VGND VPWR sky130_fd_sc_hd__tapvpwrvgnd_1
XFILLER_0_76_473 VGND VGND VPWR VPWR sky130_fd_sc_hd__decap_3
XFILLER_0_63_101 VGND VGND VPWR VPWR sky130_fd_sc_hd__decap_8
XTAP_TAPCELL_ROW_24_446 VGND VPWR sky130_fd_sc_hd__tapvpwrvgnd_1
XANTENNA__3966__A1 _1165_ VGND VGND VPWR VPWR sky130_fd_sc_hd__diode_2
XFILLER_0_36_304 VGND VGND VPWR VPWR sky130_fd_sc_hd__decap_4
XFILLER_0_8_272 VGND VGND VPWR VPWR sky130_fd_sc_hd__fill_2
XFILLER_0_8_250 VGND VGND VPWR VPWR sky130_fd_sc_hd__fill_2
XANTENNA_clkbuf_leaf_69_clk_A clknet_3_0__leaf_clk VGND VGND VPWR VPWR sky130_fd_sc_hd__diode_2
XFILLER_0_48_197 VGND VGND VPWR VPWR sky130_fd_sc_hd__fill_2
XFILLER_0_91_476 VPWR VGND VPWR VGND sky130_ef_sc_hd__decap_12
XFILLER_0_8_294 VGND VGND VPWR VPWR sky130_fd_sc_hd__fill_2
XFILLER_0_17_573 VGND VGND VPWR VPWR sky130_fd_sc_hd__fill_1
XFILLER_0_51_307 VGND VGND VPWR VPWR sky130_fd_sc_hd__decap_6
XFILLER_0_5_3 VPWR VGND VPWR VGND sky130_ef_sc_hd__decap_12
XFILLER_0_24_15 VPWR VGND VPWR VGND sky130_ef_sc_hd__decap_12
XTAP_TAPCELL_ROW_80_1010 VGND VPWR sky130_fd_sc_hd__tapvpwrvgnd_1
XFILLER_0_39_153 VGND VGND VPWR VPWR sky130_fd_sc_hd__fill_2
XFILLER_0_82_421 VGND VGND VPWR VPWR sky130_fd_sc_hd__decap_8
XFILLER_0_82_432 VGND VGND VPWR VPWR sky130_fd_sc_hd__fill_1
XFILLER_0_27_337 VGND VGND VPWR VPWR sky130_fd_sc_hd__fill_2
XFILLER_0_54_145 VGND VGND VPWR VPWR sky130_fd_sc_hd__fill_1
X_2560_ _1893_ _1897_ VGND VGND VPWR VPWR _1898_ sky130_fd_sc_hd__nor2_1
XFILLER_0_2_459 VPWR VGND VPWR VGND sky130_ef_sc_hd__decap_12
X_2491_ tree_instances\[3\].u_tree.pipeline_current_node\[0\]\[1\] VGND VGND VPWR
+ VPWR _1837_ sky130_fd_sc_hd__clkbuf_1
XFILLER_0_50_373 VPWR VGND VPWR VGND sky130_ef_sc_hd__decap_12
X_4230_ _1496_ VGND VGND VPWR VPWR _0521_ sky130_fd_sc_hd__clkbuf_1
X_4161_ _1460_ VGND VGND VPWR VPWR _0488_ sky130_fd_sc_hd__clkbuf_1
XFILLER_0_65_55 VGND VGND VPWR VPWR sky130_fd_sc_hd__fill_1
XFILLER_0_4_69 VGND VGND VPWR VPWR sky130_fd_sc_hd__decap_8
X_3112_ tree_instances\[4\].u_tree.frame_id_out\[4\] VGND VGND VPWR VPWR _0784_ sky130_fd_sc_hd__inv_2
X_4092_ tree_instances\[16\].u_tree.pipeline_frame_id\[0\]\[0\] _0664_ _0016_ VGND
+ VGND VPWR VPWR _1409_ sky130_fd_sc_hd__mux2_1
X_3043_ _0714_ tree_instances\[14\].u_tree.frame_id_out\[2\] VGND VGND VPWR VPWR _0715_
+ sky130_fd_sc_hd__and2_1
XTAP_TAPCELL_ROW_66_869 VGND VPWR sky130_fd_sc_hd__tapvpwrvgnd_1
XANTENNA__4764__RESET_B net11 VGND VGND VPWR VPWR sky130_fd_sc_hd__diode_2
XFILLER_0_81_54 VGND VGND VPWR VPWR sky130_fd_sc_hd__fill_2
X_3945_ _1333_ VGND VGND VPWR VPWR _0399_ sky130_fd_sc_hd__clkbuf_1
XFILLER_0_85_281 VGND VGND VPWR VPWR sky130_fd_sc_hd__decap_4
XTAP_TAPCELL_ROW_21_416 VGND VPWR sky130_fd_sc_hd__tapvpwrvgnd_1
X_3876_ _1284_ VGND VGND VPWR VPWR _1286_ sky130_fd_sc_hd__clkbuf_1
XFILLER_0_73_476 VGND VGND VPWR VPWR sky130_fd_sc_hd__decap_6
X_2827_ tree_instances\[0\].u_tree.pipeline_current_node\[0\]\[7\] VGND VGND VPWR
+ VPWR _2130_ sky130_fd_sc_hd__clkbuf_1
XFILLER_0_83_3 VPWR VGND VPWR VGND sky130_ef_sc_hd__decap_12
XFILLER_0_5_264 VGND VGND VPWR VPWR sky130_fd_sc_hd__fill_2
XFILLER_0_60_159 VGND VGND VPWR VPWR sky130_fd_sc_hd__fill_2
X_2758_ _2068_ VGND VGND VPWR VPWR _0087_ sky130_fd_sc_hd__clkbuf_1
X_2689_ tree_instances\[12\].u_tree.pipeline_current_node\[0\]\[3\] VGND VGND VPWR
+ VPWR _2008_ sky130_fd_sc_hd__clkbuf_1
X_4428_ clknet_leaf_55_clk _0174_ net9 VGND VGND VPWR VPWR tree_instances\[2\].u_tree.pipeline_current_node\[0\]\[6\]
+ sky130_fd_sc_hd__dfrtp_1
X_4359_ clknet_leaf_26_clk _0119_ net12 VGND VGND VPWR VPWR complete_votes\[3\] sky130_fd_sc_hd__dfrtp_1
XFILLER_0_68_237 VGND VGND VPWR VPWR sky130_fd_sc_hd__fill_2
XANTENNA__4434__RESET_B net13 VGND VGND VPWR VPWR sky130_fd_sc_hd__diode_2
XFILLER_0_96_557 VGND VGND VPWR VPWR sky130_fd_sc_hd__fill_1
XTAP_TAPCELL_ROW_37_582 VGND VPWR sky130_fd_sc_hd__tapvpwrvgnd_1
XFILLER_0_83_229 VPWR VGND VPWR VGND sky130_ef_sc_hd__decap_12
XFILLER_0_76_292 VPWR VGND VPWR VGND sky130_ef_sc_hd__decap_12
XFILLER_0_91_273 VGND VGND VPWR VPWR sky130_fd_sc_hd__decap_6
XFILLER_0_24_307 VGND VGND VPWR VPWR sky130_fd_sc_hd__fill_1
XFILLER_0_51_137 VPWR VGND VPWR VGND sky130_ef_sc_hd__decap_12
XANTENNA__3167__A _0653_ VGND VGND VPWR VPWR sky130_fd_sc_hd__diode_2
XTAP_TAPCELL_ROW_9_296 VGND VPWR sky130_fd_sc_hd__tapvpwrvgnd_1
XFILLER_0_87_513 VGND VGND VPWR VPWR sky130_fd_sc_hd__fill_1
XFILLER_0_35_36 VGND VGND VPWR VPWR sky130_fd_sc_hd__decap_8
XFILLER_0_59_237 VGND VGND VPWR VPWR sky130_fd_sc_hd__decap_6
XFILLER_0_35_69 VPWR VGND VPWR VGND sky130_ef_sc_hd__decap_12
XTAP_TAPCELL_ROW_63_839 VGND VPWR sky130_fd_sc_hd__tapvpwrvgnd_1
XFILLER_0_74_218 VGND VGND VPWR VPWR sky130_fd_sc_hd__fill_2
XFILLER_0_51_35 VGND VGND VPWR VPWR sky130_fd_sc_hd__fill_1
XFILLER_0_7_529 VPWR VGND VPWR VGND sky130_ef_sc_hd__decap_12
X_3730_ _1025_ VGND VGND VPWR VPWR _1204_ sky130_fd_sc_hd__clkbuf_1
XFILLER_0_51_57 VGND VGND VPWR VPWR sky130_fd_sc_hd__fill_2
XFILLER_0_82_262 VGND VGND VPWR VPWR sky130_fd_sc_hd__fill_2
XFILLER_0_82_240 VGND VGND VPWR VPWR sky130_fd_sc_hd__decap_3
XFILLER_0_55_454 VGND VGND VPWR VPWR sky130_fd_sc_hd__decap_8
X_3661_ _1164_ VGND VGND VPWR VPWR _0284_ sky130_fd_sc_hd__clkbuf_1
X_2612_ tree_instances\[19\].u_tree.pipeline_current_node\[0\]\[1\] tree_instances\[19\].u_tree.pipeline_current_node\[0\]\[0\]
+ VGND VGND VPWR VPWR _1940_ sky130_fd_sc_hd__or2_1
X_3592_ tree_instances\[6\].u_tree.pipeline_current_node\[0\]\[7\] VGND VGND VPWR
+ VPWR _1120_ sky130_fd_sc_hd__clkbuf_1
Xclkload33 clknet_leaf_21_clk VGND VGND VPWR VPWR clkload33/Y sky130_fd_sc_hd__inv_6
Xclkload11 clknet_leaf_70_clk VGND VGND VPWR VPWR clkload11/Y sky130_fd_sc_hd__inv_8
XFILLER_0_2_223 VGND VGND VPWR VPWR sky130_fd_sc_hd__fill_2
Xclkload44 clknet_leaf_48_clk VGND VGND VPWR VPWR clkload44/Y sky130_fd_sc_hd__inv_6
Xclkload22 clknet_leaf_10_clk VGND VGND VPWR VPWR clkload22/Y sky130_fd_sc_hd__clkinv_4
Xclkload55 clknet_leaf_30_clk VGND VGND VPWR VPWR clkload55/Y sky130_fd_sc_hd__clkinv_4
X_2543_ tree_instances\[2\].u_tree.pipeline_current_node\[0\]\[8\] VGND VGND VPWR
+ VPWR _1884_ sky130_fd_sc_hd__inv_2
XFILLER_0_23_384 VGND VGND VPWR VPWR sky130_fd_sc_hd__fill_2
Xclkload66 clknet_leaf_42_clk VGND VGND VPWR VPWR clkload66/X sky130_fd_sc_hd__clkbuf_1
X_2474_ _1812_ _1824_ VGND VGND VPWR VPWR _1825_ sky130_fd_sc_hd__nor2_1
X_4213_ tree_instances\[18\].u_tree.pipeline_frame_id\[0\]\[0\] _0664_ _0020_ VGND
+ VGND VPWR VPWR _1488_ sky130_fd_sc_hd__mux2_1
X_4144_ _1177_ VGND VGND VPWR VPWR _1447_ sky130_fd_sc_hd__clkbuf_1
XTAP_TAPCELL_ROW_79_994 VGND VPWR sky130_fd_sc_hd__tapvpwrvgnd_1
XANTENNA__4864__SET_B net10 VGND VGND VPWR VPWR sky130_fd_sc_hd__diode_2
X_4075_ _1400_ VGND VGND VPWR VPWR _0462_ sky130_fd_sc_hd__clkbuf_1
X_3026_ _0696_ tree_instances\[6\].u_tree.frame_id_out\[4\] tree_instances\[6\].u_tree.prediction_valid
+ VGND VGND VPWR VPWR _0698_ sky130_fd_sc_hd__o21ai_1
XANTENNA__3094__B2 _0697_ VGND VGND VPWR VPWR sky130_fd_sc_hd__diode_2
XANTENNA__3094__A1 _0648_ VGND VGND VPWR VPWR sky130_fd_sc_hd__diode_2
XFILLER_0_93_505 VGND VGND VPWR VPWR sky130_fd_sc_hd__decap_4
XTAP_TAPCELL_ROW_34_552 VGND VPWR sky130_fd_sc_hd__tapvpwrvgnd_1
XFILLER_0_46_421 VPWR VGND VPWR VGND sky130_ef_sc_hd__decap_12
Xclkload5 clknet_leaf_1_clk VGND VGND VPWR VPWR clkload5/Y sky130_fd_sc_hd__inv_6
X_3928_ tree_instances\[15\].u_tree.pipeline_current_node\[0\]\[5\] VGND VGND VPWR
+ VPWR _1318_ sky130_fd_sc_hd__clkbuf_1
X_3859_ _1273_ VGND VGND VPWR VPWR _0373_ sky130_fd_sc_hd__clkbuf_1
XFILLER_0_14_340 VGND VGND VPWR VPWR sky130_fd_sc_hd__fill_1
XFILLER_0_6_573 VGND VGND VPWR VPWR sky130_fd_sc_hd__fill_1
XANTENNA__4310__S _0026_ VGND VGND VPWR VPWR sky130_fd_sc_hd__diode_2
XFILLER_0_41_181 VGND VGND VPWR VPWR sky130_fd_sc_hd__fill_2
XANTENNA__4686__RESET_B net12 VGND VGND VPWR VPWR sky130_fd_sc_hd__diode_2
XTAP_TAPCELL_ROW_6_266 VGND VPWR sky130_fd_sc_hd__tapvpwrvgnd_1
XFILLER_0_5_90 VGND VGND VPWR VPWR sky130_fd_sc_hd__decap_8
XANTENNA__4615__RESET_B tree_instances\[0\].u_tree.rst_n VGND VGND VPWR VPWR sky130_fd_sc_hd__diode_2
XFILLER_0_96_321 VPWR VGND VPWR VGND sky130_ef_sc_hd__decap_12
XFILLER_0_69_524 VGND VGND VPWR VPWR sky130_fd_sc_hd__decap_4
XFILLER_0_96_365 VPWR VGND VPWR VGND sky130_ef_sc_hd__decap_12
XTAP_TAPCELL_ROW_60_809 VGND VPWR sky130_fd_sc_hd__tapvpwrvgnd_1
XFILLER_0_37_421 VGND VGND VPWR VPWR sky130_fd_sc_hd__fill_1
XFILLER_0_64_251 VGND VGND VPWR VPWR sky130_fd_sc_hd__fill_1
XFILLER_0_24_104 VGND VGND VPWR VPWR sky130_fd_sc_hd__fill_2
XFILLER_0_52_457 VPWR VGND VPWR VGND sky130_ef_sc_hd__decap_12
XFILLER_0_20_321 VGND VGND VPWR VPWR sky130_fd_sc_hd__decap_4
XFILLER_0_20_365 VGND VGND VPWR VPWR sky130_fd_sc_hd__fill_1
X_2190_ _1565_ _1572_ VGND VGND VPWR VPWR _1573_ sky130_fd_sc_hd__nor2_1
XANTENNA__4356__RESET_B net11 VGND VGND VPWR VPWR sky130_fd_sc_hd__diode_2
XTAP_TAPCELL_ROW_76_964 VGND VPWR sky130_fd_sc_hd__tapvpwrvgnd_1
XFILLER_0_1_15 VPWR VGND VPWR VGND sky130_ef_sc_hd__decap_12
XTAP_TAPCELL_ROW_86_1071 VGND VPWR sky130_fd_sc_hd__tapvpwrvgnd_1
XFILLER_0_75_505 VGND VGND VPWR VPWR sky130_fd_sc_hd__decap_3
XFILLER_0_62_45 VGND VGND VPWR VPWR sky130_fd_sc_hd__fill_1
XTAP_TAPCELL_ROW_48_688 VGND VPWR sky130_fd_sc_hd__tapvpwrvgnd_1
XFILLER_0_62_56 VPWR VGND VPWR VGND sky130_ef_sc_hd__decap_12
X_4831_ clknet_leaf_46_clk _0513_ net13 VGND VGND VPWR VPWR tree_instances\[18\].u_tree.pipeline_frame_id\[0\]\[0\]
+ sky130_fd_sc_hd__dfrtp_1
XFILLER_0_7_337 VGND VGND VPWR VPWR sky130_fd_sc_hd__fill_2
XTAP_TAPCELL_ROW_31_522 VGND VPWR sky130_fd_sc_hd__tapvpwrvgnd_1
X_4762_ clknet_leaf_49_clk _0459_ net10 VGND VGND VPWR VPWR tree_instances\[15\].u_tree.frame_id_out\[4\]
+ sky130_fd_sc_hd__dfrtp_1
X_4693_ clknet_leaf_15_clk _0397_ net11 VGND VGND VPWR VPWR tree_instances\[12\].u_tree.ready_for_next
+ sky130_fd_sc_hd__dfstp_1
X_3713_ tree_instances\[8\].u_tree.pipeline_frame_id\[0\]\[4\] _1168_ _0040_ VGND
+ VGND VPWR VPWR _1194_ sky130_fd_sc_hd__mux2_1
XFILLER_0_70_243 VGND VGND VPWR VPWR sky130_fd_sc_hd__fill_1
X_3644_ _1153_ VGND VGND VPWR VPWR _1154_ sky130_fd_sc_hd__clkbuf_1
XFILLER_0_15_148 VPWR VGND VPWR VGND sky130_ef_sc_hd__decap_12
XFILLER_0_43_468 VGND VGND VPWR VPWR sky130_fd_sc_hd__fill_2
XFILLER_0_70_265 VGND VGND VPWR VPWR sky130_fd_sc_hd__decap_4
X_3575_ _1106_ VGND VGND VPWR VPWR _1107_ sky130_fd_sc_hd__clkbuf_1
X_2526_ _1665_ tree_instances\[8\].u_tree.tree_state\[2\] VGND VGND VPWR VPWR _1870_
+ sky130_fd_sc_hd__and2b_1
XFILLER_0_87_97 VGND VGND VPWR VPWR sky130_fd_sc_hd__decap_4
X_2457_ _1807_ VGND VGND VPWR VPWR _1808_ sky130_fd_sc_hd__inv_2
XFILLER_0_46_3 VPWR VGND VPWR VGND sky130_ef_sc_hd__decap_12
X_2388_ _1735_ tree_instances\[14\].u_tree.pipeline_current_node\[0\]\[6\] VGND VGND
+ VPWR VPWR _1748_ sky130_fd_sc_hd__or2_1
XTAP_TAPCELL_ROW_39_600 VGND VPWR sky130_fd_sc_hd__tapvpwrvgnd_1
XTAP_TAPCELL_ROW_3_236 VGND VPWR sky130_fd_sc_hd__tapvpwrvgnd_1
X_4127_ _1421_ VGND VGND VPWR VPWR _1433_ sky130_fd_sc_hd__clkbuf_1
XFILLER_0_36_90 VGND VGND VPWR VPWR sky130_fd_sc_hd__decap_8
X_4058_ tree_instances\[15\].u_tree.frame_id_out\[0\] tree_instances\[15\].u_tree.pipeline_frame_id\[0\]\[0\]
+ _1936_ VGND VGND VPWR VPWR _1391_ sky130_fd_sc_hd__mux2_1
X_3009_ tree_instances\[0\].u_tree.frame_id_in\[4\] VGND VGND VPWR VPWR _0682_ sky130_fd_sc_hd__clkbuf_4
XFILLER_0_78_365 VGND VGND VPWR VPWR sky130_fd_sc_hd__fill_2
Xclkbuf_leaf_63_clk clknet_3_1__leaf_clk VGND VGND VPWR VPWR clknet_leaf_63_clk sky130_fd_sc_hd__clkbuf_4
XFILLER_0_93_335 VGND VGND VPWR VPWR sky130_fd_sc_hd__fill_1
XFILLER_0_46_251 VGND VGND VPWR VPWR sky130_fd_sc_hd__fill_1
XFILLER_0_46_273 VGND VGND VPWR VPWR sky130_fd_sc_hd__fill_2
XFILLER_0_46_284 VGND VGND VPWR VPWR sky130_fd_sc_hd__decap_3
XANTENNA__4867__RESET_B net10 VGND VGND VPWR VPWR sky130_fd_sc_hd__diode_2
XFILLER_0_69_321 VGND VGND VPWR VPWR sky130_fd_sc_hd__decap_8
XTAP_TAPCELL_ROW_73_934 VGND VPWR sky130_fd_sc_hd__tapvpwrvgnd_1
Xclkbuf_leaf_54_clk clknet_3_4__leaf_clk VGND VGND VPWR VPWR clknet_leaf_54_clk sky130_fd_sc_hd__clkbuf_4
XTAP_TAPCELL_ROW_45_658 VGND VPWR sky130_fd_sc_hd__tapvpwrvgnd_1
XFILLER_0_32_15 VGND VGND VPWR VPWR sky130_fd_sc_hd__fill_2
XFILLER_0_37_240 VGND VGND VPWR VPWR sky130_fd_sc_hd__fill_2
XFILLER_0_25_413 VGND VGND VPWR VPWR sky130_fd_sc_hd__fill_2
XFILLER_0_52_210 VGND VGND VPWR VPWR sky130_fd_sc_hd__decap_4
XFILLER_0_37_295 VGND VGND VPWR VPWR sky130_fd_sc_hd__fill_2
XFILLER_0_40_449 VPWR VGND VPWR VGND sky130_ef_sc_hd__decap_12
X_3360_ tree_instances\[2\].u_tree.pipeline_current_node\[0\]\[5\] VGND VGND VPWR
+ VPWR _0975_ sky130_fd_sc_hd__clkbuf_1
XANTENNA__4537__RESET_B net11 VGND VGND VPWR VPWR sky130_fd_sc_hd__diode_2
X_2311_ tree_instances\[7\].u_tree.pipeline_current_node\[0\]\[7\] tree_instances\[7\].u_tree.pipeline_current_node\[0\]\[8\]
+ VGND VGND VPWR VPWR _1679_ sky130_fd_sc_hd__nor2_1
XFILLER_0_0_557 VGND VGND VPWR VPWR sky130_fd_sc_hd__decap_3
XFILLER_0_57_23 VGND VGND VPWR VPWR sky130_fd_sc_hd__fill_2
XFILLER_0_57_34 VGND VGND VPWR VPWR sky130_fd_sc_hd__fill_2
X_3291_ _1832_ _0933_ _0614_ tree_instances\[0\].u_tree.ready_for_next VGND VGND VPWR
+ VPWR _0145_ sky130_fd_sc_hd__a22o_1
XFILLER_0_20_195 VGND VGND VPWR VPWR sky130_fd_sc_hd__fill_1
X_2242_ tree_instances\[17\].u_tree.pipeline_current_node\[0\]\[0\] VGND VGND VPWR
+ VPWR _1618_ sky130_fd_sc_hd__clkbuf_1
X_2173_ tree_instances\[12\].u_tree.pipeline_current_node\[0\]\[0\] VGND VGND VPWR
+ VPWR _1556_ sky130_fd_sc_hd__buf_1
XFILLER_0_73_11 VGND VGND VPWR VPWR sky130_fd_sc_hd__fill_1
XFILLER_0_79_129 VPWR VGND VPWR VGND sky130_ef_sc_hd__decap_12
XFILLER_0_73_55 VGND VGND VPWR VPWR sky130_fd_sc_hd__fill_1
XTAP_TAPCELL_ROW_0_206 VGND VPWR sky130_fd_sc_hd__tapvpwrvgnd_1
XFILLER_0_18_7 VGND VGND VPWR VPWR sky130_fd_sc_hd__fill_1
Xclkbuf_leaf_45_clk clknet_3_4__leaf_clk VGND VGND VPWR VPWR clknet_leaf_45_clk sky130_fd_sc_hd__clkbuf_4
XFILLER_0_90_305 VGND VGND VPWR VPWR sky130_fd_sc_hd__decap_3
XFILLER_0_75_368 VGND VGND VPWR VPWR sky130_fd_sc_hd__fill_1
XTAP_TAPCELL_ROW_16_371 VGND VPWR sky130_fd_sc_hd__tapvpwrvgnd_1
X_4814_ clknet_leaf_46_clk _0501_ net13 VGND VGND VPWR VPWR tree_instances\[17\].u_tree.frame_id_out\[4\]
+ sky130_fd_sc_hd__dfrtp_1
XFILLER_0_43_210 VGND VGND VPWR VPWR sky130_fd_sc_hd__decap_6
X_4745_ clknet_leaf_41_clk _0442_ net10 VGND VGND VPWR VPWR tree_instances\[15\].u_tree.pipeline_current_node\[0\]\[1\]
+ sky130_fd_sc_hd__dfrtp_1
XFILLER_0_90_349 VPWR VGND VPWR VGND sky130_ef_sc_hd__decap_12
XFILLER_0_83_390 VGND VGND VPWR VPWR sky130_fd_sc_hd__fill_2
XFILLER_0_7_167 VGND VGND VPWR VPWR sky130_fd_sc_hd__fill_1
X_4676_ clknet_leaf_17_clk _0380_ net12 VGND VGND VPWR VPWR tree_instances\[12\].u_tree.pipeline_current_node\[0\]\[2\]
+ sky130_fd_sc_hd__dfrtp_1
XANTENNA__2980__A0 _0658_ VGND VGND VPWR VPWR sky130_fd_sc_hd__diode_2
XTAP_TAPCELL_ROW_95_1159 VGND VPWR sky130_fd_sc_hd__tapvpwrvgnd_1
X_3627_ _1140_ VGND VGND VPWR VPWR _0274_ sky130_fd_sc_hd__clkbuf_1
X_3558_ _1092_ VGND VGND VPWR VPWR _1093_ sky130_fd_sc_hd__clkbuf_1
X_2509_ _1845_ _1853_ _1854_ VGND VGND VPWR VPWR _1855_ sky130_fd_sc_hd__or3_1
X_3489_ _1048_ VGND VGND VPWR VPWR _0228_ sky130_fd_sc_hd__clkbuf_1
Xclkbuf_leaf_36_clk clknet_3_7__leaf_clk VGND VGND VPWR VPWR clknet_leaf_36_clk sky130_fd_sc_hd__clkbuf_4
XTAP_TAPCELL_ROW_70_904 VGND VPWR sky130_fd_sc_hd__tapvpwrvgnd_1
XFILLER_0_39_505 VGND VGND VPWR VPWR sky130_fd_sc_hd__decap_6
XFILLER_0_78_184 VPWR VGND VPWR VGND sky130_ef_sc_hd__decap_12
XTAP_TAPCELL_ROW_42_628 VGND VPWR sky130_fd_sc_hd__tapvpwrvgnd_1
XFILLER_0_81_305 VPWR VGND VPWR VGND sky130_ef_sc_hd__decap_12
XFILLER_0_19_273 VGND VGND VPWR VPWR sky130_fd_sc_hd__decap_6
XFILLER_0_34_210 VPWR VGND VPWR VGND sky130_ef_sc_hd__decap_12
XFILLER_0_62_530 VGND VGND VPWR VPWR sky130_fd_sc_hd__fill_2
XFILLER_0_22_416 VGND VGND VPWR VPWR sky130_fd_sc_hd__fill_2
XANTENNA__2971__A0 _0651_ VGND VGND VPWR VPWR sky130_fd_sc_hd__diode_2
XANTENNA__4630__RESET_B net9 VGND VGND VPWR VPWR sky130_fd_sc_hd__diode_2
XFILLER_0_27_15 VPWR VGND VPWR VGND sky130_ef_sc_hd__decap_12
XFILLER_0_89_427 VGND VGND VPWR VPWR sky130_fd_sc_hd__fill_2
XFILLER_0_89_449 VGND VGND VPWR VPWR sky130_fd_sc_hd__decap_8
Xclkbuf_leaf_27_clk clknet_3_6__leaf_clk VGND VGND VPWR VPWR clknet_leaf_27_clk sky130_fd_sc_hd__clkbuf_4
XFILLER_0_84_121 VPWR VGND VPWR VGND sky130_ef_sc_hd__decap_12
XTAP_TAPCELL_ROW_83_1041 VGND VPWR sky130_fd_sc_hd__tapvpwrvgnd_1
X_2860_ _2158_ VGND VGND VPWR VPWR _2162_ sky130_fd_sc_hd__clkbuf_1
XFILLER_0_72_305 VGND VGND VPWR VPWR sky130_fd_sc_hd__decap_3
XFILLER_0_57_357 VGND VGND VPWR VPWR sky130_fd_sc_hd__fill_2
XFILLER_0_72_338 VGND VGND VPWR VPWR sky130_fd_sc_hd__decap_6
XTAP_TAPCELL_ROW_13_341 VGND VPWR sky130_fd_sc_hd__tapvpwrvgnd_1
X_2791_ _2095_ VGND VGND VPWR VPWR _2096_ sky130_fd_sc_hd__clkbuf_1
XFILLER_0_25_210 VPWR VGND VPWR VGND sky130_ef_sc_hd__decap_12
X_4530_ clknet_leaf_18_clk _0260_ net11 VGND VGND VPWR VPWR tree_instances\[6\].u_tree.pipeline_current_node\[0\]\[7\]
+ sky130_fd_sc_hd__dfrtp_1
XANTENNA__4789__RESET_B net10 VGND VGND VPWR VPWR sky130_fd_sc_hd__diode_2
XFILLER_0_13_427 VGND VGND VPWR VPWR sky130_fd_sc_hd__decap_4
XANTENNA__4718__RESET_B tree_instances\[0\].u_tree.rst_n VGND VGND VPWR VPWR sky130_fd_sc_hd__diode_2
X_4461_ clknet_leaf_67_clk _0202_ net9 VGND VGND VPWR VPWR tree_instances\[3\].u_tree.pipeline_frame_id\[0\]\[4\]
+ sky130_fd_sc_hd__dfrtp_1
X_3412_ _2123_ _0995_ VGND VGND VPWR VPWR _1004_ sky130_fd_sc_hd__and2_1
XFILLER_0_0_321 VPWR VGND VPWR VGND sky130_ef_sc_hd__decap_12
X_4392_ clknet_leaf_31_clk _0140_ net13 VGND VGND VPWR VPWR tree_instances\[0\].u_tree.frame_id_out\[0\]
+ sky130_fd_sc_hd__dfrtp_1
XANTENNA__4371__RESET_B net12 VGND VGND VPWR VPWR sky130_fd_sc_hd__diode_2
X_3343_ tree_instances\[2\].u_tree.pipeline_current_node\[0\]\[1\] VGND VGND VPWR
+ VPWR _0962_ sky130_fd_sc_hd__clkbuf_1
XFILLER_0_0_365 VPWR VGND VPWR VGND sky130_ef_sc_hd__decap_12
XFILLER_0_21_493 VGND VGND VPWR VPWR sky130_fd_sc_hd__fill_1
X_3274_ _0924_ VGND VGND VPWR VPWR _0137_ sky130_fd_sc_hd__clkbuf_1
XFILLER_0_84_65 VPWR VGND VPWR VGND sky130_ef_sc_hd__decap_12
X_2225_ _1601_ tree_instances\[11\].u_tree.pipeline_current_node\[0\]\[0\] VGND VGND
+ VPWR VPWR _1602_ sky130_fd_sc_hd__or2_1
XFILLER_0_95_419 VPWR VGND VPWR VGND sky130_ef_sc_hd__decap_12
XFILLER_0_95_408 VGND VGND VPWR VPWR sky130_fd_sc_hd__fill_1
Xclkbuf_leaf_18_clk clknet_3_2__leaf_clk VGND VGND VPWR VPWR clknet_leaf_18_clk sky130_fd_sc_hd__clkbuf_4
XPHY_EDGE_ROW_5_Right_5 VGND VGND VPWR VPWR sky130_fd_sc_hd__decap_3
XFILLER_0_8_421 VPWR VGND VPWR VGND sky130_ef_sc_hd__decap_12
XFILLER_0_36_519 VPWR VGND VPWR VGND sky130_ef_sc_hd__decap_12
XFILLER_0_48_346 VGND VGND VPWR VPWR sky130_fd_sc_hd__fill_1
X_2989_ tree_instances\[14\].u_tree.ready_for_next tree_instances\[17\].u_tree.ready_for_next
+ tree_instances\[19\].u_tree.ready_for_next tree_instances\[20\].u_tree.ready_for_next
+ VGND VGND VPWR VPWR _0666_ sky130_fd_sc_hd__and4_1
X_4728_ clknet_leaf_39_clk _0426_ net10 VGND VGND VPWR VPWR tree_instances\[14\].u_tree.pipeline_current_node\[0\]\[6\]
+ sky130_fd_sc_hd__dfrtp_1
XFILLER_0_16_243 VGND VGND VPWR VPWR sky130_fd_sc_hd__decap_3
XFILLER_0_71_393 VGND VGND VPWR VPWR sky130_fd_sc_hd__fill_1
X_4659_ clknet_leaf_13_clk _0364_ net12 VGND VGND VPWR VPWR tree_instances\[11\].u_tree.pipeline_current_node\[0\]\[7\]
+ sky130_fd_sc_hd__dfrtp_1
XANTENNA__4459__RESET_B net9 VGND VGND VPWR VPWR sky130_fd_sc_hd__diode_2
XFILLER_0_31_235 VPWR VGND VPWR VGND sky130_ef_sc_hd__decap_12
XTAP_TAPCELL_ROW_27_477 VGND VPWR sky130_fd_sc_hd__tapvpwrvgnd_1
XFILLER_0_94_452 VGND VGND VPWR VPWR sky130_fd_sc_hd__fill_2
XFILLER_0_13_28 VGND VGND VPWR VPWR sky130_fd_sc_hd__decap_3
XFILLER_0_39_346 VGND VGND VPWR VPWR sky130_fd_sc_hd__fill_2
XFILLER_0_66_187 VGND VGND VPWR VPWR sky130_fd_sc_hd__fill_2
XFILLER_0_27_519 VGND VGND VPWR VPWR sky130_fd_sc_hd__fill_1
XFILLER_0_54_338 VGND VGND VPWR VPWR sky130_fd_sc_hd__fill_2
XANTENNA__4882__RESET_B net10 VGND VGND VPWR VPWR sky130_fd_sc_hd__diode_2
XTAP_TAPCELL_ROW_10_311 VGND VPWR sky130_fd_sc_hd__tapvpwrvgnd_1
XANTENNA__4811__RESET_B net13 VGND VGND VPWR VPWR sky130_fd_sc_hd__diode_2
XFILLER_0_50_566 VGND VGND VPWR VPWR sky130_fd_sc_hd__decap_8
XFILLER_0_10_419 VGND VGND VPWR VPWR sky130_fd_sc_hd__fill_1
XFILLER_0_89_279 VGND VGND VPWR VPWR sky130_fd_sc_hd__fill_1
XFILLER_0_54_68 VGND VGND VPWR VPWR sky130_fd_sc_hd__decap_4
XANTENNA__3424__A1 _0682_ VGND VGND VPWR VPWR sky130_fd_sc_hd__diode_2
X_3961_ _1341_ VGND VGND VPWR VPWR _0407_ sky130_fd_sc_hd__clkbuf_1
XFILLER_0_85_441 VGND VGND VPWR VPWR sky130_fd_sc_hd__decap_6
XFILLER_0_70_23 VGND VGND VPWR VPWR sky130_fd_sc_hd__fill_2
X_2912_ _0612_ VGND VGND VPWR VPWR _0040_ sky130_fd_sc_hd__inv_2
X_3892_ _1298_ VGND VGND VPWR VPWR _0381_ sky130_fd_sc_hd__clkbuf_1
XFILLER_0_85_496 VGND VGND VPWR VPWR sky130_fd_sc_hd__fill_2
XFILLER_0_18_519 VPWR VGND VPWR VGND sky130_ef_sc_hd__decap_12
X_2843_ _2145_ VGND VGND VPWR VPWR _2146_ sky130_fd_sc_hd__clkbuf_1
XFILLER_0_72_135 VGND VGND VPWR VPWR sky130_fd_sc_hd__fill_2
X_2774_ _2078_ VGND VGND VPWR VPWR _2082_ sky130_fd_sc_hd__clkbuf_1
X_4513_ clknet_leaf_58_clk _0244_ net12 VGND VGND VPWR VPWR tree_instances\[5\].u_tree.pipeline_frame_id\[0\]\[4\]
+ sky130_fd_sc_hd__dfrtp_1
XANTENNA__4552__RESET_B net13 VGND VGND VPWR VPWR sky130_fd_sc_hd__diode_2
XFILLER_0_53_393 VGND VGND VPWR VPWR sky130_fd_sc_hd__decap_4
XTAP_TAPCELL_ROW_92_1129 VGND VPWR sky130_fd_sc_hd__tapvpwrvgnd_1
X_4444_ clknet_leaf_67_clk _0037_ net9 VGND VGND VPWR VPWR tree_instances\[7\].u_tree.tree_state\[1\]
+ sky130_fd_sc_hd__dfrtp_1
Xclkbuf_leaf_7_clk clknet_3_3__leaf_clk VGND VGND VPWR VPWR clknet_leaf_7_clk sky130_fd_sc_hd__clkbuf_4
X_4375_ clknet_leaf_33_clk _0001_ net13 VGND VGND VPWR VPWR tree_instances\[0\].u_tree.tree_state\[1\]
+ sky130_fd_sc_hd__dfrtp_1
X_3326_ tree_instances\[1\].u_tree.frame_id_out\[1\] tree_instances\[1\].u_tree.pipeline_frame_id\[0\]\[1\]
+ tree_instances\[1\].u_tree.tree_state\[3\] VGND VGND VPWR VPWR _0952_ sky130_fd_sc_hd__mux2_1
XPHY_EDGE_ROW_13_Left_110 VGND VGND VPWR VPWR sky130_fd_sc_hd__decap_3
X_3257_ _2136_ _0912_ VGND VGND VPWR VPWR _0916_ sky130_fd_sc_hd__and2_1
X_3188_ _0653_ tree_instances\[8\].u_tree.frame_id_out\[2\] VGND VGND VPWR VPWR _0860_
+ sky130_fd_sc_hd__xnor2_1
X_2208_ tree_instances\[9\].u_tree.pipeline_current_node\[0\]\[8\] _1587_ VGND VGND
+ VPWR VPWR _1588_ sky130_fd_sc_hd__nor2_1
XANTENNA__3663__A1 _1165_ VGND VGND VPWR VPWR sky130_fd_sc_hd__diode_2
XFILLER_0_63_113 VGND VGND VPWR VPWR sky130_fd_sc_hd__decap_6
XTAP_TAPCELL_ROW_24_447 VGND VPWR sky130_fd_sc_hd__tapvpwrvgnd_1
XFILLER_0_17_541 VPWR VGND VPWR VGND sky130_ef_sc_hd__decap_12
XFILLER_0_32_533 VGND VGND VPWR VPWR sky130_fd_sc_hd__fill_1
XFILLER_0_12_290 VPWR VGND VPWR VGND sky130_ef_sc_hd__decap_12
XFILLER_0_59_419 VPWR VGND VPWR VGND sky130_ef_sc_hd__decap_12
XFILLER_0_24_27 VGND VGND VPWR VPWR sky130_fd_sc_hd__fill_1
XFILLER_0_39_110 VGND VGND VPWR VPWR sky130_fd_sc_hd__fill_2
XFILLER_0_86_249 VGND VGND VPWR VPWR sky130_fd_sc_hd__decap_3
XTAP_TAPCELL_ROW_80_1011 VGND VPWR sky130_fd_sc_hd__tapvpwrvgnd_1
XANTENNA_clkbuf_3_7__f_clk_A clknet_0_clk VGND VGND VPWR VPWR sky130_fd_sc_hd__diode_2
XFILLER_0_40_26 VGND VGND VPWR VPWR sky130_fd_sc_hd__fill_2
XFILLER_0_82_477 VGND VGND VPWR VPWR sky130_fd_sc_hd__decap_6
XFILLER_0_35_393 VGND VGND VPWR VPWR sky130_fd_sc_hd__fill_1
XFILLER_0_50_330 VGND VGND VPWR VPWR sky130_fd_sc_hd__fill_2
X_2490_ _1835_ VGND VGND VPWR VPWR _1836_ sky130_fd_sc_hd__clkbuf_1
XFILLER_0_49_24 VGND VGND VPWR VPWR sky130_fd_sc_hd__fill_2
XFILLER_0_50_385 VGND VGND VPWR VPWR sky130_fd_sc_hd__decap_6
XFILLER_0_49_57 VPWR VGND VPWR VGND sky130_ef_sc_hd__decap_12
XFILLER_0_4_15 VPWR VGND VPWR VGND sky130_ef_sc_hd__decap_12
X_4160_ _1459_ _1444_ VGND VGND VPWR VPWR _1460_ sky130_fd_sc_hd__and2_1
X_3111_ tree_instances\[4\].u_tree.frame_id_out\[2\] VGND VGND VPWR VPWR _0783_ sky130_fd_sc_hd__inv_2
X_4091_ _1408_ VGND VGND VPWR VPWR _0470_ sky130_fd_sc_hd__clkbuf_1
X_3042_ _0703_ VGND VGND VPWR VPWR _0714_ sky130_fd_sc_hd__clkbuf_4
XFILLER_0_58_485 VGND VGND VPWR VPWR sky130_fd_sc_hd__fill_1
X_3944_ _2004_ _1332_ VGND VGND VPWR VPWR _1333_ sky130_fd_sc_hd__and2_1
XFILLER_0_85_293 VPWR VGND VPWR VGND sky130_ef_sc_hd__decap_12
X_3875_ _1283_ VGND VGND VPWR VPWR _1285_ sky130_fd_sc_hd__clkbuf_1
XANTENNA__4733__RESET_B net11 VGND VGND VPWR VPWR sky130_fd_sc_hd__diode_2
XTAP_TAPCELL_ROW_21_417 VGND VPWR sky130_fd_sc_hd__tapvpwrvgnd_1
XFILLER_0_45_113 VPWR VGND VPWR VGND sky130_ef_sc_hd__decap_12
X_2826_ _1632_ VGND VGND VPWR VPWR _2129_ sky130_fd_sc_hd__clkbuf_1
XFILLER_0_14_533 VPWR VGND VPWR VGND sky130_ef_sc_hd__decap_12
XFILLER_0_5_287 VGND VGND VPWR VPWR sky130_fd_sc_hd__decap_3
XFILLER_0_30_70 VGND VGND VPWR VPWR sky130_fd_sc_hd__decap_8
X_2757_ tree_instances\[11\].u_tree.prediction_valid _1595_ VGND VGND VPWR VPWR _2068_
+ sky130_fd_sc_hd__and2b_1
X_2688_ _2006_ VGND VGND VPWR VPWR _2007_ sky130_fd_sc_hd__clkbuf_1
XFILLER_0_76_3 VPWR VGND VPWR VGND sky130_ef_sc_hd__decap_12
X_4427_ clknet_leaf_55_clk _0173_ tree_instances\[0\].u_tree.rst_n VGND VGND VPWR
+ VPWR tree_instances\[2\].u_tree.pipeline_current_node\[0\]\[5\] sky130_fd_sc_hd__dfrtp_1
X_4358_ clknet_leaf_25_clk _0118_ net11 VGND VGND VPWR VPWR complete_votes\[2\] sky130_fd_sc_hd__dfrtp_1
X_3309_ _0943_ VGND VGND VPWR VPWR _0153_ sky130_fd_sc_hd__clkbuf_1
X_4289_ _1527_ VGND VGND VPWR VPWR _0549_ sky130_fd_sc_hd__clkbuf_1
XANTENNA__4308__S _0026_ VGND VGND VPWR VPWR sky130_fd_sc_hd__diode_2
XFILLER_0_68_249 VGND VGND VPWR VPWR sky130_fd_sc_hd__decap_3
XTAP_TAPCELL_ROW_37_583 VGND VPWR sky130_fd_sc_hd__tapvpwrvgnd_1
XANTENNA__4474__RESET_B tree_instances\[0\].u_tree.rst_n VGND VGND VPWR VPWR sky130_fd_sc_hd__diode_2
XANTENNA__4403__RESET_B net11 VGND VGND VPWR VPWR sky130_fd_sc_hd__diode_2
XFILLER_0_64_477 VGND VGND VPWR VPWR sky130_fd_sc_hd__fill_2
XFILLER_0_10_29 VPWR VGND VPWR VGND sky130_ef_sc_hd__decap_12
XFILLER_0_51_149 VGND VGND VPWR VPWR sky130_fd_sc_hd__decap_6
XFILLER_0_32_363 VGND VGND VPWR VPWR sky130_fd_sc_hd__fill_1
XFILLER_0_32_385 VGND VGND VPWR VPWR sky130_fd_sc_hd__fill_2
XFILLER_0_19_27 VPWR VGND VPWR VGND sky130_ef_sc_hd__decap_12
XTAP_TAPCELL_ROW_9_297 VGND VPWR sky130_fd_sc_hd__tapvpwrvgnd_1
XFILLER_0_87_558 VGND VGND VPWR VPWR sky130_fd_sc_hd__fill_2
XANTENNA__4052__A1 _0674_ VGND VGND VPWR VPWR sky130_fd_sc_hd__diode_2
XFILLER_0_27_113 VGND VGND VPWR VPWR sky130_fd_sc_hd__decap_8
XFILLER_0_51_47 VGND VGND VPWR VPWR sky130_fd_sc_hd__fill_2
XFILLER_0_51_69 VGND VGND VPWR VPWR sky130_fd_sc_hd__fill_1
XFILLER_0_27_146 VPWR VGND VPWR VGND sky130_ef_sc_hd__decap_12
XFILLER_0_82_274 VGND VGND VPWR VPWR sky130_fd_sc_hd__fill_1
XFILLER_0_70_425 VPWR VGND VPWR VGND sky130_ef_sc_hd__decap_12
XFILLER_0_15_319 VGND VGND VPWR VPWR sky130_fd_sc_hd__fill_2
X_3660_ tree_instances\[7\].u_tree.pipeline_frame_id\[0\]\[1\] _1124_ _0038_ VGND
+ VGND VPWR VPWR _1164_ sky130_fd_sc_hd__mux2_1
X_3591_ _1119_ VGND VGND VPWR VPWR _0259_ sky130_fd_sc_hd__clkbuf_1
X_2611_ _1938_ VGND VGND VPWR VPWR _1939_ sky130_fd_sc_hd__clkbuf_1
Xclkload34 clknet_leaf_22_clk VGND VGND VPWR VPWR clkload34/Y sky130_fd_sc_hd__clkinvlp_4
Xclkload12 clknet_leaf_71_clk VGND VGND VPWR VPWR clkload12/Y sky130_fd_sc_hd__inv_6
XFILLER_0_35_190 VPWR VGND VPWR VGND sky130_ef_sc_hd__decap_12
XFILLER_0_42_138 VGND VGND VPWR VPWR sky130_fd_sc_hd__fill_2
Xclkload23 clknet_leaf_11_clk VGND VGND VPWR VPWR clkload23/Y sky130_fd_sc_hd__clkinvlp_4
Xclkload56 clknet_leaf_31_clk VGND VGND VPWR VPWR clkload56/Y sky130_fd_sc_hd__bufinv_16
Xclkload67 clknet_leaf_43_clk VGND VGND VPWR VPWR clkload67/Y sky130_fd_sc_hd__clkinv_1
XFILLER_0_11_503 VGND VGND VPWR VPWR sky130_fd_sc_hd__fill_1
X_2542_ _1881_ _1882_ VGND VGND VPWR VPWR _1883_ sky130_fd_sc_hd__or2_1
Xclkload45 clknet_leaf_49_clk VGND VGND VPWR VPWR clkload45/Y sky130_fd_sc_hd__clkinv_2
XANTENNA_clkbuf_leaf_53_clk_A clknet_3_5__leaf_clk VGND VGND VPWR VPWR sky130_fd_sc_hd__diode_2
XFILLER_0_50_182 VGND VGND VPWR VPWR sky130_fd_sc_hd__decap_3
X_2473_ _1815_ _1817_ _1823_ VGND VGND VPWR VPWR _1824_ sky130_fd_sc_hd__or3_1
X_4212_ _1487_ VGND VGND VPWR VPWR _0512_ sky130_fd_sc_hd__clkbuf_1
X_4143_ _1446_ VGND VGND VPWR VPWR _0484_ sky130_fd_sc_hd__clkbuf_1
XFILLER_0_92_21 VGND VGND VPWR VPWR sky130_fd_sc_hd__decap_6
XTAP_TAPCELL_ROW_79_995 VGND VPWR sky130_fd_sc_hd__tapvpwrvgnd_1
XANTENNA_clkbuf_leaf_68_clk_A clknet_3_0__leaf_clk VGND VGND VPWR VPWR sky130_fd_sc_hd__diode_2
X_4074_ _2065_ _1399_ VGND VGND VPWR VPWR _1400_ sky130_fd_sc_hd__and2_1
X_3025_ _0696_ VGND VGND VPWR VPWR _0697_ sky130_fd_sc_hd__clkbuf_4
XFILLER_0_92_65 VGND VGND VPWR VPWR sky130_fd_sc_hd__decap_3
XTAP_TAPCELL_ROW_34_553 VGND VPWR sky130_fd_sc_hd__tapvpwrvgnd_1
XFILLER_0_46_433 VGND VGND VPWR VPWR sky130_fd_sc_hd__fill_2
X_3927_ _1690_ VGND VGND VPWR VPWR _1317_ sky130_fd_sc_hd__clkbuf_1
XFILLER_0_46_455 VGND VGND VPWR VPWR sky130_fd_sc_hd__fill_2
X_3858_ tree_instances\[11\].u_tree.frame_id_out\[2\] tree_instances\[11\].u_tree.pipeline_frame_id\[0\]\[2\]
+ _1595_ VGND VGND VPWR VPWR _1273_ sky130_fd_sc_hd__mux2_1
XFILLER_0_18_179 VGND VGND VPWR VPWR sky130_fd_sc_hd__fill_2
Xclkload6 clknet_leaf_2_clk VGND VGND VPWR VPWR clkload6/Y sky130_fd_sc_hd__bufinv_16
X_2809_ _1850_ VGND VGND VPWR VPWR _2113_ sky130_fd_sc_hd__clkbuf_1
X_3789_ _1237_ VGND VGND VPWR VPWR _0339_ sky130_fd_sc_hd__clkbuf_1
XFILLER_0_14_363 VGND VGND VPWR VPWR sky130_fd_sc_hd__fill_1
XTAP_TAPCELL_ROW_6_267 VGND VPWR sky130_fd_sc_hd__tapvpwrvgnd_1
XFILLER_0_69_503 VGND VGND VPWR VPWR sky130_fd_sc_hd__fill_1
XFILLER_0_96_333 VGND VGND VPWR VPWR sky130_fd_sc_hd__decap_3
XANTENNA__4655__RESET_B net12 VGND VGND VPWR VPWR sky130_fd_sc_hd__diode_2
XFILLER_0_96_377 VPWR VGND VPWR VGND sky130_ef_sc_hd__decap_12
XANTENNA__3178__A tree_instances\[20\].u_tree.frame_id_out\[4\] VGND VGND VPWR VPWR
+ sky130_fd_sc_hd__diode_2
XFILLER_0_52_469 VGND VGND VPWR VPWR sky130_fd_sc_hd__fill_1
XANTENNA__4870__SET_B net10 VGND VGND VPWR VPWR sky130_fd_sc_hd__diode_2
XANTENNA__3848__A1 _1165_ VGND VGND VPWR VPWR sky130_fd_sc_hd__diode_2
XTAP_TAPCELL_ROW_76_965 VGND VPWR sky130_fd_sc_hd__tapvpwrvgnd_1
XFILLER_0_1_27 VPWR VGND VPWR VGND sky130_ef_sc_hd__decap_12
XANTENNA__4396__RESET_B net13 VGND VGND VPWR VPWR sky130_fd_sc_hd__diode_2
XTAP_TAPCELL_ROW_86_1072 VGND VPWR sky130_fd_sc_hd__tapvpwrvgnd_1
XTAP_TAPCELL_ROW_48_689 VGND VPWR sky130_fd_sc_hd__tapvpwrvgnd_1
XFILLER_0_62_68 VPWR VGND VPWR VGND sky130_ef_sc_hd__decap_12
X_4830_ clknet_leaf_51_clk _0512_ net10 VGND VGND VPWR VPWR tree_instances\[18\].u_tree.pipeline_current_node\[0\]\[8\]
+ sky130_fd_sc_hd__dfrtp_1
XFILLER_0_75_539 VGND VGND VPWR VPWR sky130_fd_sc_hd__fill_1
XANTENNA__4025__A1 _1889_ VGND VGND VPWR VPWR sky130_fd_sc_hd__diode_2
XFILLER_0_7_305 VPWR VGND VPWR VGND sky130_ef_sc_hd__decap_12
XFILLER_0_83_561 VPWR VGND VPWR VGND sky130_ef_sc_hd__decap_12
XANTENNA__4622__D _0012_ VGND VGND VPWR VPWR sky130_fd_sc_hd__diode_2
XTAP_TAPCELL_ROW_31_523 VGND VPWR sky130_fd_sc_hd__tapvpwrvgnd_1
XANTENNA__3088__A _0655_ VGND VGND VPWR VPWR sky130_fd_sc_hd__diode_2
X_4761_ clknet_leaf_44_clk _0458_ net13 VGND VGND VPWR VPWR tree_instances\[15\].u_tree.frame_id_out\[3\]
+ sky130_fd_sc_hd__dfrtp_1
X_4692_ clknet_leaf_14_clk _0396_ net11 VGND VGND VPWR VPWR tree_instances\[12\].u_tree.frame_id_out\[4\]
+ sky130_fd_sc_hd__dfrtp_1
X_3712_ _1193_ VGND VGND VPWR VPWR _0306_ sky130_fd_sc_hd__clkbuf_1
X_3643_ _1152_ VGND VGND VPWR VPWR _1153_ sky130_fd_sc_hd__clkbuf_1
X_3574_ tree_instances\[6\].u_tree.pipeline_current_node\[0\]\[3\] VGND VGND VPWR
+ VPWR _1106_ sky130_fd_sc_hd__clkbuf_1
XFILLER_0_11_311 VPWR VGND VPWR VGND sky130_ef_sc_hd__decap_12
X_2525_ tree_instances\[13\].u_tree.tree_state\[2\] _1858_ _1868_ _1869_ tree_instances\[13\].u_tree.tree_state\[1\]
+ VGND VGND VPWR VPWR _0051_ sky130_fd_sc_hd__a41o_1
XFILLER_0_11_388 VGND VGND VPWR VPWR sky130_fd_sc_hd__fill_1
X_2456_ tree_instances\[4\].u_tree.pipeline_current_node\[0\]\[0\] VGND VGND VPWR
+ VPWR _1807_ sky130_fd_sc_hd__clkbuf_1
X_2387_ _1746_ VGND VGND VPWR VPWR _1747_ sky130_fd_sc_hd__clkbuf_1
XFILLER_0_39_3 VPWR VGND VPWR VGND sky130_ef_sc_hd__decap_12
XTAP_TAPCELL_ROW_39_601 VGND VPWR sky130_fd_sc_hd__tapvpwrvgnd_1
X_4126_ _1961_ VGND VGND VPWR VPWR _1432_ sky130_fd_sc_hd__clkbuf_1
XTAP_TAPCELL_ROW_3_237 VGND VPWR sky130_fd_sc_hd__tapvpwrvgnd_1
XFILLER_0_78_300 VGND VGND VPWR VPWR sky130_fd_sc_hd__fill_2
XANTENNA__2167__A tree_instances\[7\].u_tree.ready_for_next VGND VGND VPWR VPWR sky130_fd_sc_hd__diode_2
X_4057_ _1390_ VGND VGND VPWR VPWR _0454_ sky130_fd_sc_hd__clkbuf_1
XFILLER_0_78_322 VPWR VGND VPWR VGND sky130_ef_sc_hd__decap_12
X_3008_ _0681_ VGND VGND VPWR VPWR _0114_ sky130_fd_sc_hd__clkbuf_1
XANTENNA__3069__A1_N _0694_ VGND VGND VPWR VPWR sky130_fd_sc_hd__diode_2
XANTENNA__3775__B1 _0610_ VGND VGND VPWR VPWR sky130_fd_sc_hd__diode_2
XFILLER_0_61_222 VGND VGND VPWR VPWR sky130_fd_sc_hd__fill_2
XFILLER_0_6_360 VGND VGND VPWR VPWR sky130_fd_sc_hd__decap_4
XFILLER_0_34_447 VGND VGND VPWR VPWR sky130_fd_sc_hd__fill_2
XFILLER_0_6_393 VGND VGND VPWR VPWR sky130_fd_sc_hd__fill_1
XPHY_EDGE_ROW_5_Left_102 VGND VGND VPWR VPWR sky130_fd_sc_hd__decap_3
XFILLER_0_14_193 VGND VGND VPWR VPWR sky130_fd_sc_hd__decap_3
XFILLER_0_16_17 VGND VGND VPWR VPWR sky130_fd_sc_hd__fill_2
XANTENNA__4836__RESET_B net13 VGND VGND VPWR VPWR sky130_fd_sc_hd__diode_2
XTAP_TAPCELL_ROW_73_935 VGND VPWR sky130_fd_sc_hd__tapvpwrvgnd_1
XFILLER_0_96_141 VPWR VGND VPWR VGND sky130_ef_sc_hd__decap_12
XFILLER_0_69_366 VPWR VGND VPWR VGND sky130_ef_sc_hd__decap_12
XTAP_TAPCELL_ROW_45_659 VGND VPWR sky130_fd_sc_hd__tapvpwrvgnd_1
XFILLER_0_84_347 VGND VGND VPWR VPWR sky130_fd_sc_hd__fill_2
XANTENNA__4007__A1 _0672_ VGND VGND VPWR VPWR sky130_fd_sc_hd__diode_2
XFILLER_0_72_509 VGND VGND VPWR VPWR sky130_fd_sc_hd__decap_4
XFILLER_0_65_561 VPWR VGND VPWR VGND sky130_ef_sc_hd__decap_12
XFILLER_0_37_252 VGND VGND VPWR VPWR sky130_fd_sc_hd__decap_3
XFILLER_0_37_285 VGND VGND VPWR VPWR sky130_fd_sc_hd__fill_2
XFILLER_0_80_531 VGND VGND VPWR VPWR sky130_fd_sc_hd__fill_1
XFILLER_0_33_491 VGND VGND VPWR VPWR sky130_fd_sc_hd__decap_6
XFILLER_0_20_141 VPWR VGND VPWR VGND sky130_ef_sc_hd__decap_12
X_3290_ tree_instances\[0\].u_tree.tree_state\[0\] _1831_ VGND VGND VPWR VPWR _0933_
+ sky130_fd_sc_hd__nand2_1
X_2310_ _1674_ _1677_ VGND VGND VPWR VPWR _1678_ sky130_fd_sc_hd__nor2_1
XFILLER_0_20_163 VPWR VGND VPWR VGND sky130_ef_sc_hd__decap_12
X_2241_ _1616_ VGND VGND VPWR VPWR _1617_ sky130_fd_sc_hd__clkbuf_1
XFILLER_0_57_57 VPWR VGND VPWR VGND sky130_ef_sc_hd__decap_12
XANTENNA__4577__RESET_B net11 VGND VGND VPWR VPWR sky130_fd_sc_hd__diode_2
X_2172_ _1555_ VGND VGND VPWR VPWR net8 sky130_fd_sc_hd__clkbuf_2
XFILLER_0_79_108 VGND VGND VPWR VPWR sky130_fd_sc_hd__decap_4
XPHY_EDGE_ROW_69_Left_166 VGND VGND VPWR VPWR sky130_fd_sc_hd__decap_3
XTAP_TAPCELL_ROW_0_207 VGND VPWR sky130_fd_sc_hd__tapvpwrvgnd_1
XANTENNA__4506__RESET_B net13 VGND VGND VPWR VPWR sky130_fd_sc_hd__diode_2
XFILLER_0_48_506 VGND VGND VPWR VPWR sky130_fd_sc_hd__fill_1
XFILLER_0_75_325 VGND VGND VPWR VPWR sky130_fd_sc_hd__decap_4
XFILLER_0_7_113 VGND VGND VPWR VPWR sky130_fd_sc_hd__decap_6
XTAP_TAPCELL_ROW_16_372 VGND VPWR sky130_fd_sc_hd__tapvpwrvgnd_1
X_4813_ clknet_leaf_45_clk _0500_ net12 VGND VGND VPWR VPWR tree_instances\[17\].u_tree.frame_id_out\[3\]
+ sky130_fd_sc_hd__dfrtp_1
X_4744_ clknet_leaf_41_clk _0441_ net10 VGND VGND VPWR VPWR tree_instances\[15\].u_tree.pipeline_current_node\[0\]\[0\]
+ sky130_fd_sc_hd__dfrtp_1
XFILLER_0_7_179 VGND VGND VPWR VPWR sky130_fd_sc_hd__decap_3
X_4675_ clknet_leaf_17_clk _0379_ net12 VGND VGND VPWR VPWR tree_instances\[12\].u_tree.pipeline_current_node\[0\]\[1\]
+ sky130_fd_sc_hd__dfrtp_1
XPHY_EDGE_ROW_78_Left_175 VGND VGND VPWR VPWR sky130_fd_sc_hd__decap_3
X_3626_ _1137_ _1139_ VGND VGND VPWR VPWR _1140_ sky130_fd_sc_hd__and2_1
XFILLER_0_3_341 VGND VGND VPWR VPWR sky130_fd_sc_hd__fill_1
X_3557_ tree_instances\[6\].u_tree.pipeline_current_node\[0\]\[0\] VGND VGND VPWR
+ VPWR _1092_ sky130_fd_sc_hd__clkbuf_1
XFILLER_0_11_141 VGND VGND VPWR VPWR sky130_fd_sc_hd__decap_8
XFILLER_0_11_130 VGND VGND VPWR VPWR sky130_fd_sc_hd__fill_2
X_2508_ tree_instances\[3\].u_tree.pipeline_current_node\[0\]\[6\] tree_instances\[3\].u_tree.pipeline_current_node\[0\]\[7\]
+ VGND VGND VPWR VPWR _1854_ sky130_fd_sc_hd__or2_1
X_3488_ tree_instances\[4\].u_tree.frame_id_out\[4\] tree_instances\[4\].u_tree.pipeline_frame_id\[0\]\[4\]
+ tree_instances\[4\].u_tree.tree_state\[3\] VGND VGND VPWR VPWR _1048_ sky130_fd_sc_hd__mux2_1
X_2439_ _1782_ _1787_ _1790_ _1792_ VGND VGND VPWR VPWR _1793_ sky130_fd_sc_hd__and4b_1
XPHY_EDGE_ROW_87_Left_184 VGND VGND VPWR VPWR sky130_fd_sc_hd__decap_3
X_4109_ _1417_ VGND VGND VPWR VPWR _0479_ sky130_fd_sc_hd__clkbuf_1
XFILLER_0_78_141 VPWR VGND VPWR VGND sky130_ef_sc_hd__decap_12
XFILLER_0_78_130 VGND VGND VPWR VPWR sky130_fd_sc_hd__decap_3
XFILLER_0_66_303 VGND VGND VPWR VPWR sky130_fd_sc_hd__fill_2
XFILLER_0_93_100 VGND VGND VPWR VPWR sky130_fd_sc_hd__decap_4
XTAP_TAPCELL_ROW_70_905 VGND VPWR sky130_fd_sc_hd__tapvpwrvgnd_1
XANTENNA__4316__S _1908_ VGND VGND VPWR VPWR sky130_fd_sc_hd__diode_2
XFILLER_0_66_347 VGND VGND VPWR VPWR sky130_fd_sc_hd__fill_2
XTAP_TAPCELL_ROW_42_629 VGND VPWR sky130_fd_sc_hd__tapvpwrvgnd_1
XPHY_EDGE_ROW_96_Left_193 VGND VGND VPWR VPWR sky130_fd_sc_hd__decap_3
XFILLER_0_81_317 VGND VGND VPWR VPWR sky130_fd_sc_hd__decap_6
XFILLER_0_34_222 VPWR VGND VPWR VGND sky130_ef_sc_hd__decap_12
XFILLER_0_6_190 VGND VGND VPWR VPWR sky130_fd_sc_hd__decap_6
XFILLER_0_27_27 VPWR VGND VPWR VGND sky130_ef_sc_hd__decap_12
XANTENNA__3191__A _0733_ VGND VGND VPWR VPWR sky130_fd_sc_hd__diode_2
XANTENNA__4670__RESET_B tree_instances\[0\].u_tree.rst_n VGND VGND VPWR VPWR sky130_fd_sc_hd__diode_2
XTAP_TAPCELL_ROW_58_784 VGND VPWR sky130_fd_sc_hd__tapvpwrvgnd_1
XFILLER_0_69_163 VGND VGND VPWR VPWR sky130_fd_sc_hd__fill_1
XFILLER_0_43_15 VGND VGND VPWR VPWR sky130_fd_sc_hd__decap_3
XTAP_TAPCELL_ROW_83_1042 VGND VPWR sky130_fd_sc_hd__tapvpwrvgnd_1
XFILLER_0_84_133 VGND VGND VPWR VPWR sky130_fd_sc_hd__decap_6
XTAP_TAPCELL_ROW_13_342 VGND VPWR sky130_fd_sc_hd__tapvpwrvgnd_1
XFILLER_0_65_391 VGND VGND VPWR VPWR sky130_fd_sc_hd__fill_1
X_2790_ _2094_ VGND VGND VPWR VPWR _2095_ sky130_fd_sc_hd__clkbuf_1
XFILLER_0_25_222 VGND VGND VPWR VPWR sky130_fd_sc_hd__fill_2
XFILLER_0_4_127 VGND VGND VPWR VPWR sky130_fd_sc_hd__decap_8
XFILLER_0_80_394 VGND VGND VPWR VPWR sky130_fd_sc_hd__decap_3
XFILLER_0_7_15 VPWR VGND VPWR VGND sky130_ef_sc_hd__decap_12
X_4460_ clknet_leaf_62_clk _0201_ net9 VGND VGND VPWR VPWR tree_instances\[3\].u_tree.pipeline_frame_id\[0\]\[3\]
+ sky130_fd_sc_hd__dfrtp_1
XFILLER_0_40_203 VPWR VGND VPWR VGND sky130_ef_sc_hd__decap_12
X_4391_ clknet_leaf_32_clk _0139_ net13 VGND VGND VPWR VPWR tree_instances\[0\].u_tree.pipeline_frame_id\[0\]\[4\]
+ sky130_fd_sc_hd__dfrtp_1
X_3411_ _1003_ VGND VGND VPWR VPWR _0195_ sky130_fd_sc_hd__clkbuf_1
XFILLER_0_0_333 VGND VGND VPWR VPWR sky130_fd_sc_hd__decap_3
X_3342_ _0961_ VGND VGND VPWR VPWR _0168_ sky130_fd_sc_hd__clkbuf_1
XFILLER_0_0_377 VPWR VGND VPWR VGND sky130_ef_sc_hd__decap_12
XANTENNA__4758__RESET_B net10 VGND VGND VPWR VPWR sky130_fd_sc_hd__diode_2
X_3273_ tree_instances\[0\].u_tree.pipeline_frame_id\[0\]\[2\] _0675_ _0002_ VGND
+ VGND VPWR VPWR _0924_ sky130_fd_sc_hd__mux2_1
X_2224_ tree_instances\[11\].u_tree.pipeline_current_node\[0\]\[1\] VGND VGND VPWR
+ VPWR _1601_ sky130_fd_sc_hd__clkbuf_1
XFILLER_0_84_77 VGND VGND VPWR VPWR sky130_fd_sc_hd__decap_6
XANTENNA__4340__RESET_B net10 VGND VGND VPWR VPWR sky130_fd_sc_hd__diode_2
XFILLER_0_17_60 VPWR VGND VPWR VGND sky130_ef_sc_hd__decap_12
XANTENNA__4219__A1 _0678_ VGND VGND VPWR VPWR sky130_fd_sc_hd__diode_2
XFILLER_0_88_483 VGND VGND VPWR VPWR sky130_fd_sc_hd__decap_8
XFILLER_0_75_100 VPWR VGND VPWR VGND sky130_ef_sc_hd__decap_12
XFILLER_0_8_433 VPWR VGND VPWR VGND sky130_ef_sc_hd__decap_12
XFILLER_0_29_561 VPWR VGND VPWR VGND sky130_ef_sc_hd__decap_12
X_2988_ _0664_ VGND VGND VPWR VPWR _0665_ sky130_fd_sc_hd__clkbuf_4
XFILLER_0_8_477 VPWR VGND VPWR VGND sky130_ef_sc_hd__decap_12
XFILLER_0_90_169 VGND VGND VPWR VPWR sky130_fd_sc_hd__fill_1
X_4727_ clknet_leaf_38_clk _0425_ net10 VGND VGND VPWR VPWR tree_instances\[14\].u_tree.pipeline_current_node\[0\]\[5\]
+ sky130_fd_sc_hd__dfrtp_1
X_4658_ clknet_leaf_13_clk _0363_ net12 VGND VGND VPWR VPWR tree_instances\[11\].u_tree.pipeline_current_node\[0\]\[6\]
+ sky130_fd_sc_hd__dfrtp_1
XFILLER_0_16_277 VGND VGND VPWR VPWR sky130_fd_sc_hd__decap_4
X_3609_ _1129_ VGND VGND VPWR VPWR _0267_ sky130_fd_sc_hd__clkbuf_1
XFILLER_0_31_247 VGND VGND VPWR VPWR sky130_fd_sc_hd__decap_8
X_4589_ clknet_leaf_8_clk _0309_ net12 VGND VGND VPWR VPWR tree_instances\[8\].u_tree.frame_id_out\[1\]
+ sky130_fd_sc_hd__dfrtp_1
XANTENNA__4499__RESET_B tree_instances\[0\].u_tree.rst_n VGND VGND VPWR VPWR sky130_fd_sc_hd__diode_2
XANTENNA__4428__RESET_B net9 VGND VGND VPWR VPWR sky130_fd_sc_hd__diode_2
XFILLER_0_79_483 VGND VGND VPWR VPWR sky130_fd_sc_hd__fill_1
XTAP_TAPCELL_ROW_55_754 VGND VPWR sky130_fd_sc_hd__tapvpwrvgnd_1
XPHY_EDGE_ROW_11_Right_11 VGND VGND VPWR VPWR sky130_fd_sc_hd__decap_3
XTAP_TAPCELL_ROW_27_478 VGND VPWR sky130_fd_sc_hd__tapvpwrvgnd_1
XFILLER_0_39_358 VGND VGND VPWR VPWR sky130_fd_sc_hd__fill_1
XFILLER_0_66_177 VGND VGND VPWR VPWR sky130_fd_sc_hd__fill_1
XFILLER_0_81_169 VGND VGND VPWR VPWR sky130_fd_sc_hd__fill_2
XTAP_TAPCELL_ROW_10_312 VGND VPWR sky130_fd_sc_hd__tapvpwrvgnd_1
XFILLER_0_62_394 VGND VGND VPWR VPWR sky130_fd_sc_hd__fill_2
XFILLER_0_50_545 VGND VGND VPWR VPWR sky130_fd_sc_hd__decap_4
XANTENNA__4851__RESET_B net13 VGND VGND VPWR VPWR sky130_fd_sc_hd__diode_2
XPHY_EDGE_ROW_20_Right_20 VGND VGND VPWR VPWR sky130_fd_sc_hd__decap_3
XFILLER_0_38_15 VPWR VGND VPWR VGND sky130_ef_sc_hd__decap_12
XFILLER_0_89_225 VGND VGND VPWR VPWR sky130_fd_sc_hd__decap_8
XFILLER_0_54_25 VGND VGND VPWR VPWR sky130_fd_sc_hd__decap_3
XFILLER_0_54_58 VGND VGND VPWR VPWR sky130_fd_sc_hd__decap_6
X_3960_ _2003_ _1331_ VGND VGND VPWR VPWR _1341_ sky130_fd_sc_hd__and2_1
X_2911_ _0611_ _1667_ VGND VGND VPWR VPWR _0612_ sky130_fd_sc_hd__or2_1
X_3891_ _2022_ _1294_ VGND VGND VPWR VPWR _1298_ sky130_fd_sc_hd__and2_1
XFILLER_0_57_177 VGND VGND VPWR VPWR sky130_fd_sc_hd__decap_3
X_2842_ _2144_ VGND VGND VPWR VPWR _2145_ sky130_fd_sc_hd__clkbuf_1
XFILLER_0_26_531 VGND VGND VPWR VPWR sky130_fd_sc_hd__fill_1
X_2773_ tree_instances\[8\].u_tree.pipeline_current_node\[0\]\[6\] VGND VGND VPWR
+ VPWR _2081_ sky130_fd_sc_hd__clkbuf_1
XFILLER_0_72_169 VGND VGND VPWR VPWR sky130_fd_sc_hd__fill_1
XFILLER_0_72_158 VGND VGND VPWR VPWR sky130_fd_sc_hd__fill_2
X_4512_ clknet_leaf_63_clk _0243_ tree_instances\[0\].u_tree.rst_n VGND VGND VPWR
+ VPWR tree_instances\[5\].u_tree.pipeline_frame_id\[0\]\[3\] sky130_fd_sc_hd__dfrtp_1
XFILLER_0_53_361 VPWR VGND VPWR VGND sky130_ef_sc_hd__decap_12
XFILLER_0_79_55 VGND VGND VPWR VPWR sky130_fd_sc_hd__fill_1
X_4443_ clknet_leaf_62_clk _0077_ net9 VGND VGND VPWR VPWR tree_instances\[7\].u_tree.tree_state\[0\]
+ sky130_fd_sc_hd__dfstp_1
X_4374_ clknet_leaf_34_clk _0043_ net13 VGND VGND VPWR VPWR tree_instances\[0\].u_tree.tree_state\[0\]
+ sky130_fd_sc_hd__dfstp_1
XANTENNA__4592__RESET_B net12 VGND VGND VPWR VPWR sky130_fd_sc_hd__diode_2
XFILLER_0_0_141 VPWR VGND VPWR VGND sky130_ef_sc_hd__decap_12
X_3325_ _0951_ VGND VGND VPWR VPWR _0161_ sky130_fd_sc_hd__clkbuf_1
XANTENNA__4521__RESET_B tree_instances\[0\].u_tree.rst_n VGND VGND VPWR VPWR sky130_fd_sc_hd__diode_2
XFILLER_0_95_76 VPWR VGND VPWR VGND sky130_ef_sc_hd__decap_12
X_3256_ _0915_ VGND VGND VPWR VPWR _0128_ sky130_fd_sc_hd__clkbuf_1
X_2207_ tree_instances\[9\].u_tree.pipeline_current_node\[0\]\[7\] VGND VGND VPWR
+ VPWR _1587_ sky130_fd_sc_hd__clkbuf_1
X_3187_ tree_instances\[8\].u_tree.frame_id_out\[3\] VGND VGND VPWR VPWR _0859_ sky130_fd_sc_hd__inv_2
XFILLER_0_21_3 VGND VGND VPWR VPWR sky130_fd_sc_hd__decap_8
XFILLER_0_48_144 VGND VGND VPWR VPWR sky130_fd_sc_hd__fill_1
XTAP_TAPCELL_ROW_52_724 VGND VPWR sky130_fd_sc_hd__tapvpwrvgnd_1
XFILLER_0_91_401 VGND VGND VPWR VPWR sky130_fd_sc_hd__fill_1
XFILLER_0_76_486 VGND VGND VPWR VPWR sky130_fd_sc_hd__decap_3
XTAP_TAPCELL_ROW_24_448 VGND VPWR sky130_fd_sc_hd__tapvpwrvgnd_1
XFILLER_0_63_169 VGND VGND VPWR VPWR sky130_fd_sc_hd__fill_2
XFILLER_0_17_553 VGND VGND VPWR VPWR sky130_fd_sc_hd__decap_6
XFILLER_0_44_350 VGND VGND VPWR VPWR sky130_fd_sc_hd__decap_8
XANTENNA__3179__A1 _0733_ VGND VGND VPWR VPWR sky130_fd_sc_hd__diode_2
XFILLER_0_71_191 VPWR VGND VPWR VGND sky130_ef_sc_hd__decap_12
XANTENNA__4609__RESET_B tree_instances\[0\].u_tree.rst_n VGND VGND VPWR VPWR sky130_fd_sc_hd__diode_2
XTAP_TAPCELL_ROW_68_890 VGND VPWR sky130_fd_sc_hd__tapvpwrvgnd_1
XFILLER_0_67_453 VGND VGND VPWR VPWR sky130_fd_sc_hd__decap_6
XTAP_TAPCELL_ROW_80_1012 VGND VPWR sky130_fd_sc_hd__tapvpwrvgnd_1
XFILLER_0_42_309 VGND VGND VPWR VPWR sky130_fd_sc_hd__decap_4
XFILLER_0_50_342 VGND VGND VPWR VPWR sky130_fd_sc_hd__fill_2
XFILLER_0_10_239 VGND VGND VPWR VPWR sky130_fd_sc_hd__fill_1
XFILLER_0_49_69 VGND VGND VPWR VPWR sky130_fd_sc_hd__fill_1
X_3110_ _0774_ _0776_ _0781_ VGND VGND VPWR VPWR _0782_ sky130_fd_sc_hd__or3_1
XFILLER_0_4_27 VGND VGND VPWR VPWR sky130_fd_sc_hd__fill_1
XFILLER_0_65_57 VGND VGND VPWR VPWR sky130_fd_sc_hd__fill_2
X_4090_ _2062_ _1398_ VGND VGND VPWR VPWR _1408_ sky130_fd_sc_hd__and2_1
X_3041_ _0648_ tree_instances\[14\].u_tree.frame_id_out\[0\] tree_instances\[14\].u_tree.frame_id_out\[3\]
+ _0691_ VGND VGND VPWR VPWR _0713_ sky130_fd_sc_hd__a22o_1
XFILLER_0_81_78 VGND VGND VPWR VPWR sky130_fd_sc_hd__fill_1
XFILLER_0_58_464 VPWR VGND VPWR VGND sky130_ef_sc_hd__decap_12
X_3943_ _1331_ VGND VGND VPWR VPWR _1332_ sky130_fd_sc_hd__dlymetal6s2s_1
X_3874_ tree_instances\[14\].u_tree.pipeline_current_node\[0\]\[0\] VGND VGND VPWR
+ VPWR _1284_ sky130_fd_sc_hd__clkbuf_1
XFILLER_0_73_445 VGND VGND VPWR VPWR sky130_fd_sc_hd__decap_3
XFILLER_0_14_83 VGND VGND VPWR VPWR sky130_fd_sc_hd__fill_1
XTAP_TAPCELL_ROW_21_418 VGND VPWR sky130_fd_sc_hd__tapvpwrvgnd_1
XFILLER_0_45_125 VPWR VGND VPWR VGND sky130_ef_sc_hd__decap_12
X_2825_ _2126_ VGND VGND VPWR VPWR _2128_ sky130_fd_sc_hd__clkbuf_1
Xclkbuf_3_2__f_clk clknet_0_clk VGND VGND VPWR VPWR clknet_3_2__leaf_clk sky130_fd_sc_hd__clkbuf_16
XFILLER_0_5_211 VPWR VGND VPWR VGND sky130_ef_sc_hd__decap_12
XFILLER_0_14_501 VPWR VGND VPWR VGND sky130_ef_sc_hd__decap_12
XFILLER_0_26_361 VGND VGND VPWR VPWR sky130_fd_sc_hd__decap_3
XFILLER_0_14_545 VPWR VGND VPWR VGND sky130_ef_sc_hd__decap_12
XANTENNA__4773__RESET_B tree_instances\[0\].u_tree.rst_n VGND VGND VPWR VPWR sky130_fd_sc_hd__diode_2
X_2756_ _1788_ VGND VGND VPWR VPWR _2067_ sky130_fd_sc_hd__clkbuf_1
XFILLER_0_26_394 VPWR VGND VPWR VGND sky130_ef_sc_hd__decap_12
XFILLER_0_41_331 VGND VGND VPWR VPWR sky130_fd_sc_hd__fill_2
X_2687_ _1570_ VGND VGND VPWR VPWR _2006_ sky130_fd_sc_hd__clkbuf_1
XANTENNA__4702__RESET_B net9 VGND VGND VPWR VPWR sky130_fd_sc_hd__diode_2
XFILLER_0_69_3 VGND VGND VPWR VPWR sky130_fd_sc_hd__decap_8
X_4426_ clknet_leaf_55_clk _0172_ tree_instances\[0\].u_tree.rst_n VGND VGND VPWR
+ VPWR tree_instances\[2\].u_tree.pipeline_current_node\[0\]\[4\] sky130_fd_sc_hd__dfrtp_1
XFILLER_0_1_461 VPWR VGND VPWR VGND sky130_ef_sc_hd__decap_12
X_4357_ clknet_leaf_25_clk _0117_ net11 VGND VGND VPWR VPWR complete_votes\[1\] sky130_fd_sc_hd__dfrtp_1
X_3308_ _0577_ _0936_ VGND VGND VPWR VPWR _0943_ sky130_fd_sc_hd__and2_1
X_4288_ _2150_ _1524_ VGND VGND VPWR VPWR _1527_ sky130_fd_sc_hd__and2_1
X_3239_ _0649_ _0905_ VGND VGND VPWR VPWR _0121_ sky130_fd_sc_hd__nor2_1
XTAP_TAPCELL_ROW_65_860 VGND VPWR sky130_fd_sc_hd__tapvpwrvgnd_1
XFILLER_0_64_401 VGND VGND VPWR VPWR sky130_fd_sc_hd__fill_2
XANTENNA__4542__SET_B net11 VGND VGND VPWR VPWR sky130_fd_sc_hd__diode_2
XFILLER_0_64_434 VPWR VGND VPWR VGND sky130_ef_sc_hd__decap_12
XFILLER_0_9_561 VPWR VGND VPWR VGND sky130_ef_sc_hd__decap_12
XFILLER_0_24_309 VPWR VGND VPWR VGND sky130_ef_sc_hd__decap_12
XFILLER_0_17_361 VGND VGND VPWR VPWR sky130_fd_sc_hd__decap_4
XFILLER_0_51_106 VGND VGND VPWR VPWR sky130_fd_sc_hd__fill_1
XTAP_TAPCELL_ROW_9_298 VGND VPWR sky130_fd_sc_hd__tapvpwrvgnd_1
XFILLER_0_19_39 VGND VGND VPWR VPWR sky130_fd_sc_hd__fill_2
XPHY_EDGE_ROW_32_Left_129 VGND VGND VPWR VPWR sky130_fd_sc_hd__decap_3
XFILLER_0_51_15 VPWR VGND VPWR VGND sky130_ef_sc_hd__decap_12
XFILLER_0_27_158 VGND VGND VPWR VPWR sky130_fd_sc_hd__decap_8
XFILLER_0_27_169 VPWR VGND VPWR VGND sky130_ef_sc_hd__decap_12
XFILLER_0_70_437 VGND VGND VPWR VPWR sky130_fd_sc_hd__decap_6
XFILLER_0_55_489 VGND VGND VPWR VPWR sky130_fd_sc_hd__fill_2
X_2610_ tree_instances\[19\].u_tree.pipeline_current_node\[0\]\[3\] tree_instances\[19\].u_tree.pipeline_current_node\[0\]\[2\]
+ VGND VGND VPWR VPWR _1938_ sky130_fd_sc_hd__or2_1
X_3590_ _1118_ _1096_ VGND VGND VPWR VPWR _1119_ sky130_fd_sc_hd__and2_1
Xclkload35 clknet_leaf_23_clk VGND VGND VPWR VPWR clkload35/Y sky130_fd_sc_hd__inv_6
Xclkload24 clknet_leaf_13_clk VGND VGND VPWR VPWR clkload24/Y sky130_fd_sc_hd__clkinv_2
XPHY_EDGE_ROW_41_Left_138 VGND VGND VPWR VPWR sky130_fd_sc_hd__decap_3
Xclkload13 clknet_leaf_6_clk VGND VGND VPWR VPWR clkload13/Y sky130_fd_sc_hd__clkinvlp_4
Xclkload57 clknet_leaf_32_clk VGND VGND VPWR VPWR clkload57/Y sky130_fd_sc_hd__bufinv_16
X_2541_ tree_instances\[2\].u_tree.pipeline_current_node\[0\]\[6\] VGND VGND VPWR
+ VPWR _1882_ sky130_fd_sc_hd__clkbuf_1
Xclkload46 clknet_leaf_50_clk VGND VGND VPWR VPWR clkload46/Y sky130_fd_sc_hd__clkinv_4
X_2472_ _1819_ _1822_ VGND VGND VPWR VPWR _1823_ sky130_fd_sc_hd__or2_1
XFILLER_0_50_194 VGND VGND VPWR VPWR sky130_fd_sc_hd__fill_2
XFILLER_0_76_23 VGND VGND VPWR VPWR sky130_fd_sc_hd__fill_1
XFILLER_0_11_559 VGND VGND VPWR VPWR sky130_fd_sc_hd__fill_1
X_4211_ tree_instances\[18\].u_tree.pipeline_current_node\[0\]\[8\] _1477_ VGND VGND
+ VPWR VPWR _1487_ sky130_fd_sc_hd__and2_1
X_4142_ _1617_ _1444_ VGND VGND VPWR VPWR _1446_ sky130_fd_sc_hd__and2_1
XFILLER_0_92_11 VGND VGND VPWR VPWR sky130_fd_sc_hd__fill_1
X_4073_ _1398_ VGND VGND VPWR VPWR _1399_ sky130_fd_sc_hd__dlymetal6s2s_1
XPHY_EDGE_ROW_50_Left_147 VGND VGND VPWR VPWR sky130_fd_sc_hd__decap_3
XTAP_TAPCELL_ROW_79_996 VGND VPWR sky130_fd_sc_hd__tapvpwrvgnd_1
X_3024_ _0695_ VGND VGND VPWR VPWR _0696_ sky130_fd_sc_hd__clkbuf_4
XFILLER_0_92_88 VPWR VGND VPWR VGND sky130_ef_sc_hd__decap_12
XFILLER_0_25_60 VGND VGND VPWR VPWR sky130_fd_sc_hd__fill_2
XTAP_TAPCELL_ROW_62_830 VGND VPWR sky130_fd_sc_hd__tapvpwrvgnd_1
XFILLER_0_18_114 VGND VGND VPWR VPWR sky130_fd_sc_hd__fill_1
X_3926_ _1689_ VGND VGND VPWR VPWR _1316_ sky130_fd_sc_hd__clkbuf_1
XFILLER_0_6_531 VGND VGND VPWR VPWR sky130_fd_sc_hd__fill_1
Xclkload7 clknet_leaf_3_clk VGND VGND VPWR VPWR clkload7/Y sky130_fd_sc_hd__inv_6
X_3857_ _1272_ VGND VGND VPWR VPWR _0372_ sky130_fd_sc_hd__clkbuf_1
X_2808_ _2111_ VGND VGND VPWR VPWR _2112_ sky130_fd_sc_hd__clkbuf_1
X_3788_ _0590_ _1232_ VGND VGND VPWR VPWR _1237_ sky130_fd_sc_hd__and2_1
X_2739_ _1778_ VGND VGND VPWR VPWR _2050_ sky130_fd_sc_hd__clkbuf_1
XFILLER_0_41_150 VGND VGND VPWR VPWR sky130_fd_sc_hd__decap_8
XFILLER_0_41_161 VGND VGND VPWR VPWR sky130_fd_sc_hd__decap_6
X_4409_ clknet_leaf_21_clk _0156_ net11 VGND VGND VPWR VPWR tree_instances\[1\].u_tree.pipeline_frame_id\[0\]\[0\]
+ sky130_fd_sc_hd__dfrtp_1
XTAP_TAPCELL_ROW_6_268 VGND VPWR sky130_fd_sc_hd__tapvpwrvgnd_1
XFILLER_0_69_559 VGND VGND VPWR VPWR sky130_fd_sc_hd__fill_1
XFILLER_0_96_389 VGND VGND VPWR VPWR sky130_fd_sc_hd__decap_3
XANTENNA__4695__RESET_B net13 VGND VGND VPWR VPWR sky130_fd_sc_hd__diode_2
XFILLER_0_64_253 VGND VGND VPWR VPWR sky130_fd_sc_hd__decap_8
XANTENNA__3242__B1 _0655_ VGND VGND VPWR VPWR sky130_fd_sc_hd__diode_2
XFILLER_0_92_573 VGND VGND VPWR VPWR sky130_fd_sc_hd__fill_1
XFILLER_0_9_391 VGND VGND VPWR VPWR sky130_fd_sc_hd__fill_1
XANTENNA__4624__RESET_B net12 VGND VGND VPWR VPWR sky130_fd_sc_hd__diode_2
XFILLER_0_24_128 VGND VGND VPWR VPWR sky130_fd_sc_hd__decap_3
XFILLER_0_24_139 VGND VGND VPWR VPWR sky130_fd_sc_hd__fill_1
XFILLER_0_20_356 VGND VGND VPWR VPWR sky130_fd_sc_hd__decap_8
XFILLER_0_46_15 VGND VGND VPWR VPWR sky130_fd_sc_hd__decap_8
XFILLER_0_46_26 VGND VGND VPWR VPWR sky130_fd_sc_hd__fill_2
XFILLER_0_87_312 VGND VGND VPWR VPWR sky130_fd_sc_hd__decap_4
XTAP_TAPCELL_ROW_76_966 VGND VPWR sky130_fd_sc_hd__tapvpwrvgnd_1
XFILLER_0_87_345 VGND VGND VPWR VPWR sky130_fd_sc_hd__fill_1
XTAP_TAPCELL_ROW_86_1073 VGND VPWR sky130_fd_sc_hd__tapvpwrvgnd_1
XFILLER_0_62_25 VGND VGND VPWR VPWR sky130_fd_sc_hd__decap_3
XFILLER_0_1_39 VPWR VGND VPWR VGND sky130_ef_sc_hd__decap_12
XFILLER_0_28_412 VGND VGND VPWR VPWR sky130_fd_sc_hd__fill_2
XFILLER_0_83_551 VGND VGND VPWR VPWR sky130_fd_sc_hd__decap_8
XFILLER_0_7_317 VPWR VGND VPWR VGND sky130_ef_sc_hd__decap_12
XFILLER_0_28_445 VPWR VGND VPWR VGND sky130_ef_sc_hd__decap_12
X_4760_ clknet_leaf_42_clk _0457_ net10 VGND VGND VPWR VPWR tree_instances\[15\].u_tree.frame_id_out\[2\]
+ sky130_fd_sc_hd__dfrtp_1
XFILLER_0_55_242 VPWR VGND VPWR VGND sky130_ef_sc_hd__decap_12
XFILLER_0_83_573 VGND VGND VPWR VPWR sky130_fd_sc_hd__fill_1
X_4691_ clknet_leaf_14_clk _0395_ net12 VGND VGND VPWR VPWR tree_instances\[12\].u_tree.frame_id_out\[3\]
+ sky130_fd_sc_hd__dfrtp_1
XFILLER_0_70_201 VGND VGND VPWR VPWR sky130_fd_sc_hd__decap_8
X_3711_ tree_instances\[8\].u_tree.pipeline_frame_id\[0\]\[3\] _1192_ _0040_ VGND
+ VGND VPWR VPWR _1193_ sky130_fd_sc_hd__mux2_1
XANTENNA__4365__RESET_B net12 VGND VGND VPWR VPWR sky130_fd_sc_hd__diode_2
XFILLER_0_43_426 VGND VGND VPWR VPWR sky130_fd_sc_hd__fill_2
X_3642_ tree_instances\[7\].u_tree.pipeline_current_node\[0\]\[4\] VGND VGND VPWR
+ VPWR _1152_ sky130_fd_sc_hd__clkbuf_1
X_3573_ _1105_ VGND VGND VPWR VPWR _0255_ sky130_fd_sc_hd__clkbuf_1
XFILLER_0_70_289 VGND VGND VPWR VPWR sky130_fd_sc_hd__fill_2
XFILLER_0_11_323 VPWR VGND VPWR VGND sky130_ef_sc_hd__decap_12
XFILLER_0_23_172 VPWR VGND VPWR VGND sky130_ef_sc_hd__decap_12
XPHY_EDGE_ROW_49_Right_49 VGND VGND VPWR VPWR sky130_fd_sc_hd__decap_3
XFILLER_0_51_492 VPWR VGND VPWR VGND sky130_ef_sc_hd__decap_12
XFILLER_0_11_345 VGND VGND VPWR VPWR sky130_fd_sc_hd__fill_1
X_2524_ tree_instances\[13\].u_tree.pipeline_current_node\[0\]\[8\] tree_instances\[13\].u_tree.pipeline_current_node\[0\]\[7\]
+ VGND VGND VPWR VPWR _1869_ sky130_fd_sc_hd__nor2_1
XFILLER_0_11_378 VGND VGND VPWR VPWR sky130_fd_sc_hd__fill_2
X_2455_ _1806_ VGND VGND VPWR VPWR _0003_ sky130_fd_sc_hd__clkbuf_1
X_2386_ tree_instances\[14\].u_tree.pipeline_current_node\[0\]\[5\] tree_instances\[14\].u_tree.pipeline_current_node\[0\]\[4\]
+ VGND VGND VPWR VPWR _1746_ sky130_fd_sc_hd__or2_1
X_4125_ _1430_ VGND VGND VPWR VPWR _1431_ sky130_fd_sc_hd__clkbuf_1
XTAP_TAPCELL_ROW_3_238 VGND VPWR sky130_fd_sc_hd__tapvpwrvgnd_1
XTAP_TAPCELL_ROW_39_602 VGND VPWR sky130_fd_sc_hd__tapvpwrvgnd_1
XPHY_EDGE_ROW_58_Right_58 VGND VGND VPWR VPWR sky130_fd_sc_hd__decap_3
X_4056_ tree_instances\[15\].u_tree.pipeline_frame_id\[0\]\[4\] tree_instances\[0\].u_tree.frame_id_in\[4\]
+ _0014_ VGND VGND VPWR VPWR _1390_ sky130_fd_sc_hd__mux2_1
XFILLER_0_78_334 VGND VGND VPWR VPWR sky130_fd_sc_hd__decap_4
X_3007_ _0679_ _0680_ VGND VGND VPWR VPWR _0681_ sky130_fd_sc_hd__and2_1
XFILLER_0_93_304 VGND VGND VPWR VPWR sky130_fd_sc_hd__fill_2
XFILLER_0_46_231 VGND VGND VPWR VPWR sky130_fd_sc_hd__fill_2
XFILLER_0_52_80 VGND VGND VPWR VPWR sky130_fd_sc_hd__fill_2
X_3909_ tree_instances\[12\].u_tree.pipeline_frame_id\[0\]\[3\] _1192_ _0008_ VGND
+ VGND VPWR VPWR _1307_ sky130_fd_sc_hd__mux2_1
X_4889_ clknet_leaf_26_clk _0561_ net12 VGND VGND VPWR VPWR tree_instances\[20\].u_tree.frame_id_out\[0\]
+ sky130_fd_sc_hd__dfrtp_1
XRandom_forest_top_ver3_14 VGND VGND VPWR VPWR Random_forest_top_ver3_14/HI prediction_out
+ sky130_fd_sc_hd__conb_1
XFILLER_0_34_459 VPWR VGND VPWR VGND sky130_ef_sc_hd__decap_12
XPHY_EDGE_ROW_67_Right_67 VGND VGND VPWR VPWR sky130_fd_sc_hd__decap_3
XFILLER_0_61_267 VPWR VGND VPWR VGND sky130_ef_sc_hd__decap_12
XPHY_EDGE_ROW_76_Right_76 VGND VGND VPWR VPWR sky130_fd_sc_hd__decap_3
XTAP_TAPCELL_ROW_73_936 VGND VPWR sky130_fd_sc_hd__tapvpwrvgnd_1
XANTENNA__4876__RESET_B net10 VGND VGND VPWR VPWR sky130_fd_sc_hd__diode_2
XFILLER_0_96_153 VPWR VGND VPWR VGND sky130_ef_sc_hd__decap_12
XFILLER_0_69_378 VGND VGND VPWR VPWR sky130_fd_sc_hd__decap_8
XFILLER_0_57_518 VPWR VGND VPWR VGND sky130_ef_sc_hd__decap_12
XANTENNA__4805__RESET_B net11 VGND VGND VPWR VPWR sky130_fd_sc_hd__diode_2
XFILLER_0_96_197 VPWR VGND VPWR VGND sky130_ef_sc_hd__decap_12
XFILLER_0_69_389 VGND VGND VPWR VPWR sky130_fd_sc_hd__decap_3
XANTENNA_clkbuf_leaf_52_clk_A clknet_3_5__leaf_clk VGND VGND VPWR VPWR sky130_fd_sc_hd__diode_2
XFILLER_0_65_573 VGND VGND VPWR VPWR sky130_fd_sc_hd__fill_1
XFILLER_0_92_392 VGND VGND VPWR VPWR sky130_fd_sc_hd__decap_6
XPHY_EDGE_ROW_85_Right_85 VGND VGND VPWR VPWR sky130_fd_sc_hd__decap_3
XFILLER_0_4_309 VPWR VGND VPWR VGND sky130_ef_sc_hd__decap_12
XANTENNA_clkbuf_leaf_67_clk_A clknet_3_1__leaf_clk VGND VGND VPWR VPWR sky130_fd_sc_hd__diode_2
XFILLER_0_52_223 VGND VGND VPWR VPWR sky130_fd_sc_hd__fill_2
XFILLER_0_52_245 VGND VGND VPWR VPWR sky130_fd_sc_hd__fill_1
XFILLER_0_52_256 VPWR VGND VPWR VGND sky130_ef_sc_hd__decap_12
XFILLER_0_33_481 VGND VGND VPWR VPWR sky130_fd_sc_hd__decap_6
XFILLER_0_20_120 VPWR VGND VPWR VGND sky130_ef_sc_hd__decap_12
XFILLER_0_20_153 VGND VGND VPWR VPWR sky130_fd_sc_hd__decap_6
XFILLER_0_20_175 VPWR VGND VPWR VGND sky130_ef_sc_hd__decap_12
X_2240_ tree_instances\[17\].u_tree.pipeline_current_node\[0\]\[1\] VGND VGND VPWR
+ VPWR _1616_ sky130_fd_sc_hd__clkbuf_1
XFILLER_0_20_197 VPWR VGND VPWR VGND sky130_ef_sc_hd__decap_12
XPHY_EDGE_ROW_94_Right_94 VGND VGND VPWR VPWR sky130_fd_sc_hd__decap_3
XFILLER_0_57_69 VPWR VGND VPWR VGND sky130_ef_sc_hd__decap_12
X_2171_ _1549_ _1552_ _1554_ VGND VGND VPWR VPWR _1555_ sky130_fd_sc_hd__and3_1
XFILLER_0_73_35 VPWR VGND VPWR VGND sky130_ef_sc_hd__decap_12
XTAP_TAPCELL_ROW_0_208 VGND VPWR sky130_fd_sc_hd__tapvpwrvgnd_1
XFILLER_0_48_518 VGND VGND VPWR VPWR sky130_fd_sc_hd__fill_1
XANTENNA__4546__RESET_B net12 VGND VGND VPWR VPWR sky130_fd_sc_hd__diode_2
XFILLER_0_7_103 VGND VGND VPWR VPWR sky130_fd_sc_hd__decap_4
XTAP_TAPCELL_ROW_16_373 VGND VPWR sky130_fd_sc_hd__tapvpwrvgnd_1
X_4812_ clknet_leaf_60_clk _0499_ net12 VGND VGND VPWR VPWR tree_instances\[17\].u_tree.frame_id_out\[2\]
+ sky130_fd_sc_hd__dfrtp_1
XFILLER_0_83_370 VGND VGND VPWR VPWR sky130_fd_sc_hd__decap_4
X_4743_ clknet_leaf_67_clk _0440_ net9 VGND VGND VPWR VPWR tree_instances\[3\].u_tree.pipeline_valid\[0\]
+ sky130_fd_sc_hd__dfrtp_1
XFILLER_0_16_448 VGND VGND VPWR VPWR sky130_fd_sc_hd__decap_8
X_4674_ clknet_leaf_17_clk _0378_ net11 VGND VGND VPWR VPWR tree_instances\[12\].u_tree.pipeline_current_node\[0\]\[0\]
+ sky130_fd_sc_hd__dfrtp_1
XFILLER_0_31_418 VGND VGND VPWR VPWR sky130_fd_sc_hd__fill_2
XFILLER_0_43_267 VGND VGND VPWR VPWR sky130_fd_sc_hd__decap_4
X_3625_ _1138_ VGND VGND VPWR VPWR _1139_ sky130_fd_sc_hd__buf_1
X_3556_ _1595_ _1091_ _0006_ tree_instances\[11\].u_tree.pipeline_valid\[0\] VGND
+ VGND VPWR VPWR _0252_ sky130_fd_sc_hd__o2bb2a_1
X_2507_ _1847_ _1852_ VGND VGND VPWR VPWR _1853_ sky130_fd_sc_hd__nand2_1
X_3487_ _1047_ VGND VGND VPWR VPWR _0227_ sky130_fd_sc_hd__clkbuf_1
XFILLER_0_51_3 VPWR VGND VPWR VGND sky130_ef_sc_hd__decap_12
X_2438_ _1791_ VGND VGND VPWR VPWR _1792_ sky130_fd_sc_hd__clkbuf_1
X_2369_ _1729_ _1730_ VGND VGND VPWR VPWR _1731_ sky130_fd_sc_hd__or2_1
X_4108_ tree_instances\[16\].u_tree.frame_id_out\[3\] tree_instances\[16\].u_tree.pipeline_frame_id\[0\]\[3\]
+ _1729_ VGND VGND VPWR VPWR _1417_ sky130_fd_sc_hd__mux2_1
X_4039_ _1381_ VGND VGND VPWR VPWR _0445_ sky130_fd_sc_hd__clkbuf_1
XFILLER_0_78_197 VGND VGND VPWR VPWR sky130_fd_sc_hd__fill_2
XTAP_TAPCELL_ROW_70_906 VGND VPWR sky130_fd_sc_hd__tapvpwrvgnd_1
XFILLER_0_66_359 VGND VGND VPWR VPWR sky130_fd_sc_hd__fill_2
XFILLER_0_47_573 VGND VGND VPWR VPWR sky130_fd_sc_hd__fill_1
XFILLER_0_34_234 VPWR VGND VPWR VGND sky130_ef_sc_hd__decap_12
XFILLER_0_34_267 VPWR VGND VPWR VGND sky130_ef_sc_hd__decap_12
XFILLER_0_30_473 VGND VGND VPWR VPWR sky130_fd_sc_hd__fill_1
XFILLER_0_27_39 VPWR VGND VPWR VGND sky130_ef_sc_hd__decap_12
XFILLER_0_89_407 VGND VGND VPWR VPWR sky130_fd_sc_hd__decap_6
XTAP_TAPCELL_ROW_58_785 VGND VPWR sky130_fd_sc_hd__tapvpwrvgnd_1
XTAP_TAPCELL_ROW_83_1043 VGND VPWR sky130_fd_sc_hd__tapvpwrvgnd_1
XFILLER_0_72_318 VGND VGND VPWR VPWR sky130_fd_sc_hd__fill_2
XTAP_TAPCELL_ROW_13_343 VGND VPWR sky130_fd_sc_hd__tapvpwrvgnd_1
XANTENNA__2551__A _1666_ VGND VGND VPWR VPWR sky130_fd_sc_hd__diode_2
XFILLER_0_25_234 VGND VGND VPWR VPWR sky130_fd_sc_hd__fill_2
XFILLER_0_25_267 VGND VGND VPWR VPWR sky130_fd_sc_hd__fill_2
XFILLER_0_7_27 VPWR VGND VPWR VGND sky130_ef_sc_hd__decap_12
XFILLER_0_40_215 VGND VGND VPWR VPWR sky130_fd_sc_hd__decap_8
X_4390_ clknet_leaf_30_clk _0138_ net11 VGND VGND VPWR VPWR tree_instances\[0\].u_tree.pipeline_frame_id\[0\]\[3\]
+ sky130_fd_sc_hd__dfrtp_1
X_3410_ _2121_ _0996_ VGND VGND VPWR VPWR _1003_ sky130_fd_sc_hd__and2_1
XFILLER_0_21_440 VGND VGND VPWR VPWR sky130_fd_sc_hd__decap_6
XFILLER_0_40_248 VGND VGND VPWR VPWR sky130_fd_sc_hd__decap_4
XTAP_TAPCELL_ROW_94_1150 VGND VPWR sky130_fd_sc_hd__tapvpwrvgnd_1
XANTENNA__3911__A1 _1168_ VGND VGND VPWR VPWR sky130_fd_sc_hd__diode_2
X_3341_ _0958_ _0960_ VGND VGND VPWR VPWR _0961_ sky130_fd_sc_hd__and2_1
XANTENNA__4519__SET_B net13 VGND VGND VPWR VPWR sky130_fd_sc_hd__diode_2
XFILLER_0_68_79 VGND VGND VPWR VPWR sky130_fd_sc_hd__decap_4
XFILLER_0_0_389 VGND VGND VPWR VPWR sky130_fd_sc_hd__decap_3
X_3272_ _0923_ VGND VGND VPWR VPWR _0136_ sky130_fd_sc_hd__clkbuf_1
X_2223_ _1599_ VGND VGND VPWR VPWR _1600_ sky130_fd_sc_hd__clkbuf_1
XANTENNA__4798__RESET_B net13 VGND VGND VPWR VPWR sky130_fd_sc_hd__diode_2
XANTENNA__4727__RESET_B net10 VGND VGND VPWR VPWR sky130_fd_sc_hd__diode_2
XFILLER_0_17_72 VPWR VGND VPWR VGND sky130_ef_sc_hd__decap_12
XFILLER_0_17_94 VPWR VGND VPWR VGND sky130_ef_sc_hd__decap_12
XFILLER_0_88_495 VPWR VGND VPWR VGND sky130_ef_sc_hd__decap_12
XANTENNA__4380__RESET_B net10 VGND VGND VPWR VPWR sky130_fd_sc_hd__diode_2
XFILLER_0_75_145 VGND VGND VPWR VPWR sky130_fd_sc_hd__decap_3
XFILLER_0_90_104 VPWR VGND VPWR VGND sky130_ef_sc_hd__decap_12
XFILLER_0_63_307 VPWR VGND VPWR VGND sky130_ef_sc_hd__decap_12
XFILLER_0_8_445 VPWR VGND VPWR VGND sky130_ef_sc_hd__decap_12
XFILLER_0_29_573 VGND VGND VPWR VPWR sky130_fd_sc_hd__fill_1
XFILLER_0_33_93 VGND VGND VPWR VPWR sky130_fd_sc_hd__fill_2
X_2987_ tree_instances\[0\].u_tree.frame_id_in\[0\] VGND VGND VPWR VPWR _0664_ sky130_fd_sc_hd__buf_2
XFILLER_0_8_489 VPWR VGND VPWR VGND sky130_ef_sc_hd__decap_12
XFILLER_0_16_201 VGND VGND VPWR VPWR sky130_fd_sc_hd__fill_1
XFILLER_0_56_381 VGND VGND VPWR VPWR sky130_fd_sc_hd__fill_1
X_4726_ clknet_leaf_38_clk _0424_ net10 VGND VGND VPWR VPWR tree_instances\[14\].u_tree.pipeline_current_node\[0\]\[4\]
+ sky130_fd_sc_hd__dfrtp_1
X_4657_ clknet_leaf_12_clk _0362_ tree_instances\[0\].u_tree.rst_n VGND VGND VPWR
+ VPWR tree_instances\[11\].u_tree.pipeline_current_node\[0\]\[5\] sky130_fd_sc_hd__dfrtp_1
X_3608_ tree_instances\[6\].u_tree.frame_id_out\[0\] tree_instances\[6\].u_tree.pipeline_frame_id\[0\]\[0\]
+ _1750_ VGND VGND VPWR VPWR _1129_ sky130_fd_sc_hd__mux2_1
XFILLER_0_12_440 VGND VGND VPWR VPWR sky130_fd_sc_hd__decap_8
X_4588_ clknet_leaf_24_clk _0308_ net11 VGND VGND VPWR VPWR tree_instances\[8\].u_tree.frame_id_out\[0\]
+ sky130_fd_sc_hd__dfrtp_1
XFILLER_0_3_194 VGND VGND VPWR VPWR sky130_fd_sc_hd__fill_2
X_3539_ tree_instances\[5\].u_tree.pipeline_frame_id\[0\]\[4\] _0682_ _0034_ VGND
+ VGND VPWR VPWR _1083_ sky130_fd_sc_hd__mux2_1
XANTENNA__4468__RESET_B tree_instances\[0\].u_tree.rst_n VGND VGND VPWR VPWR sky130_fd_sc_hd__diode_2
XFILLER_0_79_473 VGND VGND VPWR VPWR sky130_fd_sc_hd__fill_2
XTAP_TAPCELL_ROW_55_755 VGND VPWR sky130_fd_sc_hd__tapvpwrvgnd_1
XTAP_TAPCELL_ROW_27_479 VGND VPWR sky130_fd_sc_hd__tapvpwrvgnd_1
XFILLER_0_39_337 VGND VGND VPWR VPWR sky130_fd_sc_hd__fill_1
XFILLER_0_81_137 VGND VGND VPWR VPWR sky130_fd_sc_hd__decap_8
XFILLER_0_47_370 VGND VGND VPWR VPWR sky130_fd_sc_hd__fill_2
XTAP_TAPCELL_ROW_10_313 VGND VPWR sky130_fd_sc_hd__tapvpwrvgnd_1
XFILLER_0_62_362 VGND VGND VPWR VPWR sky130_fd_sc_hd__fill_2
XFILLER_0_22_248 VGND VGND VPWR VPWR sky130_fd_sc_hd__fill_1
XFILLER_0_38_27 VGND VGND VPWR VPWR sky130_fd_sc_hd__fill_1
XANTENNA__4891__RESET_B net11 VGND VGND VPWR VPWR sky130_fd_sc_hd__diode_2
XANTENNA__4820__RESET_B net11 VGND VGND VPWR VPWR sky130_fd_sc_hd__diode_2
XFILLER_0_54_48 VGND VGND VPWR VPWR sky130_fd_sc_hd__decap_8
XANTENNA_clkload0_A clknet_3_1__leaf_clk VGND VGND VPWR VPWR sky130_fd_sc_hd__diode_2
XANTENNA__2980__S _0645_ VGND VGND VPWR VPWR sky130_fd_sc_hd__diode_2
X_2910_ tree_instances\[8\].u_tree.tree_state\[0\] VGND VGND VPWR VPWR _0611_ sky130_fd_sc_hd__inv_2
XFILLER_0_57_123 VPWR VGND VPWR VGND sky130_ef_sc_hd__decap_12
XANTENNA__3133__A_N _0654_ VGND VGND VPWR VPWR sky130_fd_sc_hd__diode_2
X_3890_ _1297_ VGND VGND VPWR VPWR _0380_ sky130_fd_sc_hd__clkbuf_1
X_2841_ tree_instances\[20\].u_tree.pipeline_current_node\[0\]\[4\] VGND VGND VPWR
+ VPWR _2144_ sky130_fd_sc_hd__clkbuf_1
X_2772_ tree_instances\[8\].u_tree.pipeline_current_node\[0\]\[8\] VGND VGND VPWR
+ VPWR _2080_ sky130_fd_sc_hd__clkbuf_1
X_4511_ clknet_leaf_61_clk _0242_ tree_instances\[0\].u_tree.rst_n VGND VGND VPWR
+ VPWR tree_instances\[5\].u_tree.pipeline_frame_id\[0\]\[2\] sky130_fd_sc_hd__dfrtp_1
XFILLER_0_53_373 VPWR VGND VPWR VGND sky130_ef_sc_hd__decap_12
XFILLER_0_80_181 VGND VGND VPWR VPWR sky130_fd_sc_hd__fill_1
X_4442_ clknet_leaf_59_clk _0098_ net12 VGND VGND VPWR VPWR tree_instances\[2\].u_tree.prediction_valid
+ sky130_fd_sc_hd__dfrtp_1
X_4373_ clknet_leaf_13_clk _0080_ net12 VGND VGND VPWR VPWR tree_instances\[8\].u_tree.tree_state\[3\]
+ sky130_fd_sc_hd__dfrtp_1
XFILLER_0_0_153 VPWR VGND VPWR VGND sky130_ef_sc_hd__decap_12
XFILLER_0_95_55 VGND VGND VPWR VPWR sky130_fd_sc_hd__fill_1
X_3324_ tree_instances\[1\].u_tree.frame_id_out\[0\] tree_instances\[1\].u_tree.pipeline_frame_id\[0\]\[0\]
+ tree_instances\[1\].u_tree.tree_state\[3\] VGND VGND VPWR VPWR _0951_ sky130_fd_sc_hd__mux2_1
XFILLER_0_0_197 VPWR VGND VPWR VGND sky130_ef_sc_hd__decap_12
XFILLER_0_95_88 VPWR VGND VPWR VGND sky130_ef_sc_hd__decap_12
X_3255_ _2131_ _0912_ VGND VGND VPWR VPWR _0915_ sky130_fd_sc_hd__and2_1
X_2206_ _1583_ _1585_ VGND VGND VPWR VPWR _1586_ sky130_fd_sc_hd__nor2_1
XFILLER_0_28_60 VPWR VGND VPWR VGND sky130_ef_sc_hd__decap_12
XFILLER_0_28_93 VGND VGND VPWR VPWR sky130_fd_sc_hd__fill_2
X_3186_ _0689_ tree_instances\[8\].u_tree.frame_id_out\[3\] _0856_ _0857_ tree_instances\[8\].u_tree.prediction_valid
+ VGND VGND VPWR VPWR _0858_ sky130_fd_sc_hd__o221a_1
XANTENNA__4561__RESET_B net9 VGND VGND VPWR VPWR sky130_fd_sc_hd__diode_2
XFILLER_0_14_3 VPWR VGND VPWR VGND sky130_ef_sc_hd__decap_12
XFILLER_0_76_410 VGND VGND VPWR VPWR sky130_fd_sc_hd__decap_8
XFILLER_0_76_421 VPWR VGND VPWR VGND sky130_ef_sc_hd__decap_12
XFILLER_0_44_81 VGND VGND VPWR VPWR sky130_fd_sc_hd__decap_3
XTAP_TAPCELL_ROW_52_725 VGND VPWR sky130_fd_sc_hd__tapvpwrvgnd_1
XFILLER_0_76_465 VGND VGND VPWR VPWR sky130_fd_sc_hd__decap_8
XTAP_TAPCELL_ROW_24_449 VGND VPWR sky130_fd_sc_hd__tapvpwrvgnd_1
XFILLER_0_48_167 VGND VGND VPWR VPWR sky130_fd_sc_hd__decap_3
XFILLER_0_36_329 VGND VGND VPWR VPWR sky130_fd_sc_hd__decap_4
X_4709_ clknet_leaf_1_clk _0412_ net9 VGND VGND VPWR VPWR tree_instances\[13\].u_tree.pipeline_frame_id\[0\]\[4\]
+ sky130_fd_sc_hd__dfrtp_1
XFILLER_0_71_181 VGND VGND VPWR VPWR sky130_fd_sc_hd__fill_2
XANTENNA__4649__RESET_B net9 VGND VGND VPWR VPWR sky130_fd_sc_hd__diode_2
XTAP_TAPCELL_ROW_68_891 VGND VPWR sky130_fd_sc_hd__tapvpwrvgnd_1
XFILLER_0_24_29 VGND VGND VPWR VPWR sky130_fd_sc_hd__decap_6
XFILLER_0_79_281 VPWR VGND VPWR VGND sky130_ef_sc_hd__decap_12
XFILLER_0_82_402 VGND VGND VPWR VPWR sky130_fd_sc_hd__fill_2
XTAP_TAPCELL_ROW_80_1013 VGND VPWR sky130_fd_sc_hd__tapvpwrvgnd_1
XFILLER_0_39_178 VGND VGND VPWR VPWR sky130_fd_sc_hd__decap_4
XFILLER_0_35_340 VGND VGND VPWR VPWR sky130_fd_sc_hd__fill_2
XFILLER_0_54_148 VGND VGND VPWR VPWR sky130_fd_sc_hd__fill_2
XFILLER_0_50_365 VGND VGND VPWR VPWR sky130_fd_sc_hd__fill_2
XTAP_TAPCELL_ROW_91_1120 VGND VPWR sky130_fd_sc_hd__tapvpwrvgnd_1
XANTENNA__2550__B1 _1889_ VGND VGND VPWR VPWR sky130_fd_sc_hd__diode_2
X_3040_ _0701_ _0706_ _0711_ VGND VGND VPWR VPWR _0712_ sky130_fd_sc_hd__or3b_1
XANTENNA__2276__A _1574_ VGND VGND VPWR VPWR sky130_fd_sc_hd__diode_2
XFILLER_0_81_35 VGND VGND VPWR VPWR sky130_fd_sc_hd__fill_2
XFILLER_0_77_207 VPWR VGND VPWR VGND sky130_ef_sc_hd__decap_12
XFILLER_0_58_421 VGND VGND VPWR VPWR sky130_fd_sc_hd__fill_2
XFILLER_0_85_262 VGND VGND VPWR VPWR sky130_fd_sc_hd__fill_2
XFILLER_0_18_307 VGND VGND VPWR VPWR sky130_fd_sc_hd__fill_1
X_3942_ tree_instances\[13\].u_tree.tree_state\[1\] tree_instances\[13\].u_tree.tree_state\[2\]
+ _0602_ VGND VGND VPWR VPWR _1331_ sky130_fd_sc_hd__or3_1
X_3873_ _1741_ VGND VGND VPWR VPWR _1283_ sky130_fd_sc_hd__clkbuf_1
XFILLER_0_73_435 VGND VGND VPWR VPWR sky130_fd_sc_hd__fill_1
XFILLER_0_14_73 VGND VGND VPWR VPWR sky130_fd_sc_hd__fill_1
X_2824_ tree_instances\[0\].u_tree.pipeline_current_node\[0\]\[2\] VGND VGND VPWR
+ VPWR _2127_ sky130_fd_sc_hd__clkbuf_1
XTAP_TAPCELL_ROW_21_419 VGND VPWR sky130_fd_sc_hd__tapvpwrvgnd_1
XFILLER_0_45_137 VPWR VGND VPWR VGND sky130_ef_sc_hd__decap_12
XFILLER_0_45_159 VGND VGND VPWR VPWR sky130_fd_sc_hd__decap_4
XFILLER_0_14_513 VPWR VGND VPWR VGND sky130_ef_sc_hd__decap_12
XFILLER_0_5_223 VGND VGND VPWR VPWR sky130_fd_sc_hd__fill_1
XFILLER_0_14_557 VPWR VGND VPWR VGND sky130_ef_sc_hd__decap_12
X_2755_ _2055_ VGND VGND VPWR VPWR _2066_ sky130_fd_sc_hd__clkbuf_1
XFILLER_0_53_181 VPWR VGND VPWR VGND sky130_ef_sc_hd__decap_12
X_2686_ _2005_ VGND VGND VPWR VPWR _0098_ sky130_fd_sc_hd__clkbuf_1
X_4425_ clknet_leaf_55_clk _0171_ tree_instances\[0\].u_tree.rst_n VGND VGND VPWR
+ VPWR tree_instances\[2\].u_tree.pipeline_current_node\[0\]\[3\] sky130_fd_sc_hd__dfrtp_1
XANTENNA__4742__RESET_B net11 VGND VGND VPWR VPWR sky130_fd_sc_hd__diode_2
X_4356_ clknet_leaf_24_clk _0116_ net11 VGND VGND VPWR VPWR complete_votes\[0\] sky130_fd_sc_hd__dfrtp_1
XFILLER_0_1_473 VPWR VGND VPWR VGND sky130_ef_sc_hd__decap_12
X_3307_ _0942_ VGND VGND VPWR VPWR _0152_ sky130_fd_sc_hd__clkbuf_1
XFILLER_0_39_81 VGND VGND VPWR VPWR sky130_fd_sc_hd__decap_3
X_4287_ _1526_ VGND VGND VPWR VPWR _0548_ sky130_fd_sc_hd__clkbuf_1
X_3238_ _0726_ _0000_ VGND VGND VPWR VPWR _0905_ sky130_fd_sc_hd__nor2_1
XFILLER_0_96_505 VPWR VGND VPWR VGND sky130_ef_sc_hd__decap_12
X_3169_ _0657_ _0838_ _0839_ _0840_ tree_instances\[11\].u_tree.prediction_valid VGND
+ VGND VPWR VPWR _0841_ sky130_fd_sc_hd__o221a_1
XTAP_TAPCELL_ROW_65_861 VGND VPWR sky130_fd_sc_hd__tapvpwrvgnd_1
XTAP_TAPCELL_ROW_37_574 VGND VPWR sky130_fd_sc_hd__tapvpwrvgnd_1
XFILLER_0_49_432 VGND VGND VPWR VPWR sky130_fd_sc_hd__fill_2
XFILLER_0_49_443 VGND VGND VPWR VPWR sky130_fd_sc_hd__decap_4
XFILLER_0_64_446 VPWR VGND VPWR VGND sky130_ef_sc_hd__decap_12
XFILLER_0_9_573 VGND VGND VPWR VPWR sky130_fd_sc_hd__fill_1
XANTENNA__4551__D _0018_ VGND VGND VPWR VPWR sky130_fd_sc_hd__diode_2
XANTENNA__3021__A1 _0686_ VGND VGND VPWR VPWR sky130_fd_sc_hd__diode_2
XANTENNA__3021__B2 _0691_ VGND VGND VPWR VPWR sky130_fd_sc_hd__diode_2
XFILLER_0_44_181 VGND VGND VPWR VPWR sky130_fd_sc_hd__decap_3
XFILLER_0_32_365 VPWR VGND VPWR VGND sky130_ef_sc_hd__decap_12
XFILLER_0_3_3 VGND VGND VPWR VPWR sky130_fd_sc_hd__fill_2
XANTENNA__4483__RESET_B net9 VGND VGND VPWR VPWR sky130_fd_sc_hd__diode_2
XTAP_TAPCELL_ROW_9_299 VGND VPWR sky130_fd_sc_hd__tapvpwrvgnd_1
XANTENNA__4412__RESET_B net11 VGND VGND VPWR VPWR sky130_fd_sc_hd__diode_2
XFILLER_0_35_28 VGND VGND VPWR VPWR sky130_fd_sc_hd__fill_2
XFILLER_0_87_538 VPWR VGND VPWR VGND sky130_ef_sc_hd__decap_12
XFILLER_0_87_505 VGND VGND VPWR VPWR sky130_fd_sc_hd__decap_8
XFILLER_0_51_27 VGND VGND VPWR VPWR sky130_fd_sc_hd__decap_8
XFILLER_0_55_413 VGND VGND VPWR VPWR sky130_fd_sc_hd__fill_2
XFILLER_0_55_446 VGND VGND VPWR VPWR sky130_fd_sc_hd__fill_2
XFILLER_0_70_416 VGND VGND VPWR VPWR sky130_fd_sc_hd__decap_4
Xclkload25 clknet_leaf_14_clk VGND VGND VPWR VPWR clkload25/Y sky130_fd_sc_hd__bufinv_16
Xclkload14 clknet_leaf_60_clk VGND VGND VPWR VPWR clkload14/Y sky130_fd_sc_hd__inv_8
Xclkload58 clknet_leaf_34_clk VGND VGND VPWR VPWR clkload58/Y sky130_fd_sc_hd__inv_6
Xclkload36 clknet_leaf_24_clk VGND VGND VPWR VPWR clkload36/Y sky130_fd_sc_hd__inv_6
XFILLER_0_11_505 VPWR VGND VPWR VGND sky130_ef_sc_hd__decap_12
X_2540_ tree_instances\[2\].u_tree.pipeline_current_node\[0\]\[7\] VGND VGND VPWR
+ VPWR _1881_ sky130_fd_sc_hd__clkbuf_1
XFILLER_0_23_354 VPWR VGND VPWR VGND sky130_ef_sc_hd__decap_12
Xclkload47 clknet_leaf_51_clk VGND VGND VPWR VPWR clkload47/Y sky130_fd_sc_hd__clkinvlp_4
X_2471_ _1821_ VGND VGND VPWR VPWR _1822_ sky130_fd_sc_hd__clkbuf_1
XFILLER_0_50_162 VPWR VGND VPWR VGND sky130_ef_sc_hd__decap_12
X_4210_ _1486_ VGND VGND VPWR VPWR _0511_ sky130_fd_sc_hd__clkbuf_1
X_4141_ _1445_ VGND VGND VPWR VPWR _0483_ sky130_fd_sc_hd__clkbuf_1
XANTENNA__3079__A1 _0685_ VGND VGND VPWR VPWR sky130_fd_sc_hd__diode_2
XANTENNA__3079__B2 _0657_ VGND VGND VPWR VPWR sky130_fd_sc_hd__diode_2
X_4072_ tree_instances\[16\].u_tree.tree_state\[2\] tree_instances\[16\].u_tree.tree_state\[1\]
+ _1397_ VGND VGND VPWR VPWR _1398_ sky130_fd_sc_hd__or3_1
XFILLER_0_92_45 VPWR VGND VPWR VGND sky130_ef_sc_hd__decap_12
XTAP_TAPCELL_ROW_79_997 VGND VPWR sky130_fd_sc_hd__tapvpwrvgnd_1
X_3023_ current_voting_frame\[4\] VGND VGND VPWR VPWR _0695_ sky130_fd_sc_hd__inv_2
XFILLER_0_78_549 VGND VGND VPWR VPWR sky130_fd_sc_hd__fill_1
XTAP_TAPCELL_ROW_62_831 VGND VPWR sky130_fd_sc_hd__tapvpwrvgnd_1
XTAP_TAPCELL_ROW_34_544 VGND VPWR sky130_fd_sc_hd__tapvpwrvgnd_1
XFILLER_0_46_402 VGND VGND VPWR VPWR sky130_fd_sc_hd__fill_2
X_3925_ tree_instances\[15\].u_tree.pipeline_current_node\[0\]\[0\] VGND VGND VPWR
+ VPWR _1315_ sky130_fd_sc_hd__clkbuf_1
Xclkload8 clknet_leaf_5_clk VGND VGND VPWR VPWR clkload8/Y sky130_fd_sc_hd__clkinv_4
XFILLER_0_41_93 VGND VGND VPWR VPWR sky130_fd_sc_hd__fill_1
X_3856_ tree_instances\[11\].u_tree.frame_id_out\[1\] tree_instances\[11\].u_tree.pipeline_frame_id\[0\]\[1\]
+ _1595_ VGND VGND VPWR VPWR _1272_ sky130_fd_sc_hd__mux2_1
XFILLER_0_81_3 VGND VGND VPWR VPWR sky130_fd_sc_hd__decap_6
XFILLER_0_73_298 VPWR VGND VPWR VGND sky130_ef_sc_hd__decap_12
X_2807_ _2110_ VGND VGND VPWR VPWR _2111_ sky130_fd_sc_hd__clkbuf_1
X_3787_ _1236_ VGND VGND VPWR VPWR _0338_ sky130_fd_sc_hd__clkbuf_1
XFILLER_0_14_365 VPWR VGND VPWR VGND sky130_ef_sc_hd__decap_12
X_2738_ tree_instances\[16\].u_tree.pipeline_current_node\[0\]\[2\] VGND VGND VPWR
+ VPWR _2049_ sky130_fd_sc_hd__clkbuf_1
X_4408_ clknet_leaf_31_clk _0155_ net13 VGND VGND VPWR VPWR tree_instances\[1\].u_tree.pipeline_current_node\[0\]\[8\]
+ sky130_fd_sc_hd__dfrtp_1
X_2669_ _1990_ VGND VGND VPWR VPWR _1991_ sky130_fd_sc_hd__clkbuf_1
XFILLER_0_41_195 VGND VGND VPWR VPWR sky130_fd_sc_hd__fill_2
XANTENNA__2909__A _0610_ VGND VGND VPWR VPWR sky130_fd_sc_hd__diode_2
X_4339_ clknet_leaf_48_clk _0020_ net10 VGND VGND VPWR VPWR tree_instances\[18\].u_tree.tree_state\[2\]
+ sky130_fd_sc_hd__dfrtp_1
XTAP_TAPCELL_ROW_6_269 VGND VPWR sky130_fd_sc_hd__tapvpwrvgnd_1
XFILLER_0_69_505 VGND VGND VPWR VPWR sky130_fd_sc_hd__decap_4
Xclkbuf_leaf_66_clk clknet_3_1__leaf_clk VGND VGND VPWR VPWR clknet_leaf_66_clk sky130_fd_sc_hd__clkbuf_4
XANTENNA__4333__SET_B net11 VGND VGND VPWR VPWR sky130_fd_sc_hd__diode_2
XFILLER_0_69_549 VGND VGND VPWR VPWR sky130_fd_sc_hd__fill_2
XFILLER_0_84_508 VGND VGND VPWR VPWR sky130_fd_sc_hd__decap_4
XFILLER_0_37_413 VGND VGND VPWR VPWR sky130_fd_sc_hd__decap_8
XANTENNA__3242__A1 _0651_ VGND VGND VPWR VPWR sky130_fd_sc_hd__diode_2
XFILLER_0_49_273 VGND VGND VPWR VPWR sky130_fd_sc_hd__fill_2
XFILLER_0_64_221 VGND VGND VPWR VPWR sky130_fd_sc_hd__fill_1
XFILLER_0_37_446 VGND VGND VPWR VPWR sky130_fd_sc_hd__fill_2
XFILLER_0_64_276 VGND VGND VPWR VPWR sky130_fd_sc_hd__fill_2
XANTENNA__4664__RESET_B tree_instances\[0\].u_tree.rst_n VGND VGND VPWR VPWR sky130_fd_sc_hd__diode_2
XFILLER_0_60_471 VGND VGND VPWR VPWR sky130_fd_sc_hd__fill_2
XFILLER_0_20_302 VGND VGND VPWR VPWR sky130_fd_sc_hd__decap_6
XTAP_TAPCELL_ROW_76_967 VGND VPWR sky130_fd_sc_hd__tapvpwrvgnd_1
Xclkbuf_leaf_57_clk clknet_3_4__leaf_clk VGND VGND VPWR VPWR clknet_leaf_57_clk sky130_fd_sc_hd__clkbuf_4
X_3710_ tree_instances\[0\].u_tree.frame_id_in\[3\] VGND VGND VPWR VPWR _1192_ sky130_fd_sc_hd__clkbuf_4
XFILLER_0_7_329 VGND VGND VPWR VPWR sky130_fd_sc_hd__decap_6
XFILLER_0_28_457 VPWR VGND VPWR VGND sky130_ef_sc_hd__decap_12
XTAP_TAPCELL_ROW_31_514 VGND VPWR sky130_fd_sc_hd__tapvpwrvgnd_1
XFILLER_0_55_221 VGND VGND VPWR VPWR sky130_fd_sc_hd__decap_3
X_4690_ clknet_leaf_9_clk _0394_ net11 VGND VGND VPWR VPWR tree_instances\[12\].u_tree.frame_id_out\[2\]
+ sky130_fd_sc_hd__dfrtp_1
XFILLER_0_55_254 VGND VGND VPWR VPWR sky130_fd_sc_hd__fill_1
XFILLER_0_70_213 VPWR VGND VPWR VGND sky130_ef_sc_hd__decap_12
X_3641_ _1151_ VGND VGND VPWR VPWR _0277_ sky130_fd_sc_hd__clkbuf_1
XFILLER_0_43_449 VGND VGND VPWR VPWR sky130_fd_sc_hd__decap_4
XFILLER_0_55_298 VGND VGND VPWR VPWR sky130_fd_sc_hd__fill_1
X_3572_ _1104_ _1096_ VGND VGND VPWR VPWR _1105_ sky130_fd_sc_hd__and2_1
XFILLER_0_70_246 VGND VGND VPWR VPWR sky130_fd_sc_hd__decap_4
XFILLER_0_11_302 VGND VGND VPWR VPWR sky130_fd_sc_hd__decap_6
X_2523_ _1861_ _1863_ _1867_ VGND VGND VPWR VPWR _1868_ sky130_fd_sc_hd__and3_1
XANTENNA__4334__RESET_B net11 VGND VGND VPWR VPWR sky130_fd_sc_hd__diode_2
XFILLER_0_11_335 VGND VGND VPWR VPWR sky130_fd_sc_hd__fill_1
X_2454_ _1805_ tree_instances\[10\].u_tree.tree_state\[2\] VGND VGND VPWR VPWR _1806_
+ sky130_fd_sc_hd__and2b_1
X_2385_ tree_instances\[14\].u_tree.tree_state\[2\] _1734_ _1737_ _1745_ tree_instances\[14\].u_tree.tree_state\[1\]
+ VGND VGND VPWR VPWR _0053_ sky130_fd_sc_hd__a41o_1
X_4124_ _1425_ VGND VGND VPWR VPWR _1430_ sky130_fd_sc_hd__clkbuf_1
Xinput1 feature_valid VGND VGND VPWR VPWR net1 sky130_fd_sc_hd__buf_2
XTAP_TAPCELL_ROW_3_239 VGND VPWR sky130_fd_sc_hd__tapvpwrvgnd_1
XTAP_TAPCELL_ROW_39_603 VGND VPWR sky130_fd_sc_hd__tapvpwrvgnd_1
XFILLER_0_36_71 VPWR VGND VPWR VGND sky130_ef_sc_hd__decap_12
Xclkbuf_leaf_48_clk clknet_3_5__leaf_clk VGND VGND VPWR VPWR clknet_leaf_48_clk sky130_fd_sc_hd__clkbuf_4
X_4055_ _1389_ VGND VGND VPWR VPWR _0453_ sky130_fd_sc_hd__clkbuf_1
X_3006_ _0678_ _0677_ VGND VGND VPWR VPWR _0680_ sky130_fd_sc_hd__nand2_1
XANTENNA__3472__A1 _0673_ VGND VGND VPWR VPWR sky130_fd_sc_hd__diode_2
XTAP_TAPCELL_ROW_47_680 VGND VPWR sky130_fd_sc_hd__tapvpwrvgnd_1
XFILLER_0_93_327 VGND VGND VPWR VPWR sky130_fd_sc_hd__fill_1
XFILLER_0_46_243 VGND VGND VPWR VPWR sky130_fd_sc_hd__decap_8
X_3908_ _1306_ VGND VGND VPWR VPWR _0389_ sky130_fd_sc_hd__clkbuf_1
X_4888_ clknet_leaf_42_clk _0560_ net10 VGND VGND VPWR VPWR tree_instances\[20\].u_tree.pipeline_frame_id\[0\]\[4\]
+ sky130_fd_sc_hd__dfrtp_1
X_3839_ _1263_ VGND VGND VPWR VPWR _0363_ sky130_fd_sc_hd__clkbuf_1
XFILLER_0_46_298 VGND VGND VPWR VPWR sky130_fd_sc_hd__decap_3
XFILLER_0_61_279 VGND VGND VPWR VPWR sky130_fd_sc_hd__fill_1
Xclkbuf_leaf_39_clk clknet_3_7__leaf_clk VGND VGND VPWR VPWR clknet_leaf_39_clk sky130_fd_sc_hd__clkbuf_4
XTAP_TAPCELL_ROW_73_937 VGND VPWR sky130_fd_sc_hd__tapvpwrvgnd_1
XFILLER_0_69_357 VGND VGND VPWR VPWR sky130_fd_sc_hd__fill_2
XFILLER_0_96_165 VGND VGND VPWR VPWR sky130_fd_sc_hd__decap_3
XFILLER_0_32_29 VGND VGND VPWR VPWR sky130_fd_sc_hd__fill_2
XFILLER_0_65_541 VGND VGND VPWR VPWR sky130_fd_sc_hd__decap_4
XANTENNA__4845__RESET_B net10 VGND VGND VPWR VPWR sky130_fd_sc_hd__diode_2
XFILLER_0_80_533 VGND VGND VPWR VPWR sky130_fd_sc_hd__fill_2
XFILLER_0_25_427 VGND VGND VPWR VPWR sky130_fd_sc_hd__decap_8
XFILLER_0_25_438 VGND VGND VPWR VPWR sky130_fd_sc_hd__decap_4
XFILLER_0_52_268 VPWR VGND VPWR VGND sky130_ef_sc_hd__decap_12
XFILLER_0_40_419 VGND VGND VPWR VPWR sky130_fd_sc_hd__fill_1
XFILLER_0_0_505 VPWR VGND VPWR VGND sky130_ef_sc_hd__decap_12
XFILLER_0_20_132 VGND VGND VPWR VPWR sky130_fd_sc_hd__decap_8
XFILLER_0_57_15 VGND VGND VPWR VPWR sky130_fd_sc_hd__decap_8
XFILLER_0_20_187 VGND VGND VPWR VPWR sky130_fd_sc_hd__decap_8
X_2170_ tree_instances\[19\].u_tree.ready_for_next tree_instances\[18\].u_tree.ready_for_next
+ tree_instances\[20\].u_tree.ready_for_next _1553_ VGND VGND VPWR VPWR _1554_ sky130_fd_sc_hd__and4_1
XTAP_TAPCELL_ROW_0_209 VGND VPWR sky130_fd_sc_hd__tapvpwrvgnd_1
XFILLER_0_73_47 VGND VGND VPWR VPWR sky130_fd_sc_hd__fill_2
XFILLER_0_87_143 VGND VGND VPWR VPWR sky130_fd_sc_hd__fill_2
XFILLER_0_87_176 VGND VGND VPWR VPWR sky130_fd_sc_hd__fill_2
XFILLER_0_75_316 VGND VGND VPWR VPWR sky130_fd_sc_hd__decap_3
XFILLER_0_75_305 VGND VGND VPWR VPWR sky130_fd_sc_hd__fill_2
X_4811_ clknet_leaf_58_clk _0498_ net13 VGND VGND VPWR VPWR tree_instances\[17\].u_tree.frame_id_out\[1\]
+ sky130_fd_sc_hd__dfrtp_1
XTAP_TAPCELL_ROW_44_650 VGND VPWR sky130_fd_sc_hd__tapvpwrvgnd_1
XFILLER_0_87_198 VGND VGND VPWR VPWR sky130_fd_sc_hd__fill_2
XFILLER_0_68_390 VPWR VGND VPWR VGND sky130_ef_sc_hd__decap_12
XANTENNA__3206__A1 _0702_ VGND VGND VPWR VPWR sky130_fd_sc_hd__diode_2
XFILLER_0_71_500 VGND VGND VPWR VPWR sky130_fd_sc_hd__fill_2
X_4742_ clknet_leaf_27_clk _0090_ net11 VGND VGND VPWR VPWR tree_instances\[14\].u_tree.prediction_valid
+ sky130_fd_sc_hd__dfrtp_1
XANTENNA__4586__RESET_B net12 VGND VGND VPWR VPWR sky130_fd_sc_hd__diode_2
XFILLER_0_7_126 VGND VGND VPWR VPWR sky130_fd_sc_hd__decap_4
XFILLER_0_83_393 VGND VGND VPWR VPWR sky130_fd_sc_hd__fill_2
X_4673_ clknet_leaf_19_clk _0377_ net11 VGND VGND VPWR VPWR tree_instances\[6\].u_tree.pipeline_valid\[0\]
+ sky130_fd_sc_hd__dfrtp_1
XFILLER_0_28_298 VGND VGND VPWR VPWR sky130_fd_sc_hd__fill_2
XANTENNA__4515__RESET_B tree_instances\[0\].u_tree.rst_n VGND VGND VPWR VPWR sky130_fd_sc_hd__diode_2
XFILLER_0_43_235 VGND VGND VPWR VPWR sky130_fd_sc_hd__fill_1
X_3624_ tree_instances\[7\].u_tree.tree_state\[2\] tree_instances\[7\].u_tree.tree_state\[1\]
+ _0616_ VGND VGND VPWR VPWR _1138_ sky130_fd_sc_hd__or3_1
X_3555_ tree_instances\[11\].u_tree.tree_state\[0\] _1594_ VGND VGND VPWR VPWR _1091_
+ sky130_fd_sc_hd__nand2_1
XFILLER_0_11_110 VGND VGND VPWR VPWR sky130_fd_sc_hd__fill_2
X_2506_ _1851_ VGND VGND VPWR VPWR _1852_ sky130_fd_sc_hd__clkbuf_1
X_3486_ tree_instances\[4\].u_tree.frame_id_out\[3\] tree_instances\[4\].u_tree.pipeline_frame_id\[0\]\[3\]
+ _1834_ VGND VGND VPWR VPWR _1047_ sky130_fd_sc_hd__mux2_1
X_2437_ tree_instances\[16\].u_tree.pipeline_current_node\[0\]\[8\] VGND VGND VPWR
+ VPWR _1791_ sky130_fd_sc_hd__inv_2
XFILLER_0_44_3 VPWR VGND VPWR VGND sky130_ef_sc_hd__decap_12
X_2368_ _1575_ tree_instances\[16\].u_tree.pipeline_valid\[0\] tree_instances\[16\].u_tree.tree_state\[0\]
+ VGND VGND VPWR VPWR _1730_ sky130_fd_sc_hd__o21a_1
XFILLER_0_47_70 VGND VGND VPWR VPWR sky130_fd_sc_hd__fill_2
X_2299_ tree_instances\[8\].u_tree.tree_state\[0\] _1667_ _1668_ VGND VGND VPWR VPWR
+ _0079_ sky130_fd_sc_hd__a21o_1
X_4107_ _1416_ VGND VGND VPWR VPWR _0478_ sky130_fd_sc_hd__clkbuf_1
XFILLER_0_47_92 VGND VGND VPWR VPWR sky130_fd_sc_hd__fill_2
XFILLER_0_78_110 VGND VGND VPWR VPWR sky130_fd_sc_hd__decap_8
XFILLER_0_2_61 VGND VGND VPWR VPWR sky130_fd_sc_hd__decap_3
X_4038_ _1323_ _1376_ VGND VGND VPWR VPWR _1381_ sky130_fd_sc_hd__and2_1
XANTENNA__2194__A _1575_ VGND VGND VPWR VPWR sky130_fd_sc_hd__diode_2
XTAP_TAPCELL_ROW_70_907 VGND VPWR sky130_fd_sc_hd__tapvpwrvgnd_1
XFILLER_0_66_327 VGND VGND VPWR VPWR sky130_fd_sc_hd__fill_1
XFILLER_0_47_541 VGND VGND VPWR VPWR sky130_fd_sc_hd__decap_8
XFILLER_0_62_533 VGND VGND VPWR VPWR sky130_fd_sc_hd__decap_4
XFILLER_0_22_408 VGND VGND VPWR VPWR sky130_fd_sc_hd__decap_8
XFILLER_0_34_246 VGND VGND VPWR VPWR sky130_fd_sc_hd__decap_6
XFILLER_0_15_460 VGND VGND VPWR VPWR sky130_fd_sc_hd__fill_1
XFILLER_0_34_279 VPWR VGND VPWR VGND sky130_ef_sc_hd__decap_12
XFILLER_0_30_430 VGND VGND VPWR VPWR sky130_fd_sc_hd__decap_3
XFILLER_0_89_419 VGND VGND VPWR VPWR sky130_fd_sc_hd__fill_1
XTAP_TAPCELL_ROW_58_786 VGND VPWR sky130_fd_sc_hd__tapvpwrvgnd_1
XFILLER_0_43_28 VGND VGND VPWR VPWR sky130_fd_sc_hd__fill_2
XFILLER_0_57_305 VPWR VGND VPWR VGND sky130_ef_sc_hd__decap_12
XFILLER_0_84_157 VGND VGND VPWR VPWR sky130_fd_sc_hd__fill_2
XTAP_TAPCELL_ROW_41_620 VGND VPWR sky130_fd_sc_hd__tapvpwrvgnd_1
XFILLER_0_65_393 VGND VGND VPWR VPWR sky130_fd_sc_hd__decap_4
XFILLER_0_65_371 VPWR VGND VPWR VGND sky130_ef_sc_hd__decap_12
XFILLER_0_13_408 VGND VGND VPWR VPWR sky130_fd_sc_hd__decap_4
XFILLER_0_80_363 VGND VGND VPWR VPWR sky130_fd_sc_hd__fill_1
XFILLER_0_25_279 VGND VGND VPWR VPWR sky130_fd_sc_hd__fill_1
XFILLER_0_7_39 VPWR VGND VPWR VGND sky130_ef_sc_hd__decap_12
XTAP_TAPCELL_ROW_94_1151 VGND VPWR sky130_fd_sc_hd__tapvpwrvgnd_1
X_3340_ _0959_ VGND VGND VPWR VPWR _0960_ sky130_fd_sc_hd__buf_1
XFILLER_0_21_485 VGND VGND VPWR VPWR sky130_fd_sc_hd__decap_8
X_3271_ tree_instances\[0\].u_tree.pipeline_frame_id\[0\]\[1\] _0673_ _0002_ VGND
+ VGND VPWR VPWR _0923_ sky130_fd_sc_hd__mux2_1
X_2222_ tree_instances\[11\].u_tree.pipeline_current_node\[0\]\[2\] VGND VGND VPWR
+ VPWR _1599_ sky130_fd_sc_hd__clkbuf_1
XFILLER_0_88_441 VGND VGND VPWR VPWR sky130_fd_sc_hd__fill_2
XFILLER_0_17_84 VGND VGND VPWR VPWR sky130_fd_sc_hd__decap_4
XANTENNA__4767__RESET_B net10 VGND VGND VPWR VPWR sky130_fd_sc_hd__diode_2
XFILLER_0_75_113 VPWR VGND VPWR VGND sky130_ef_sc_hd__decap_12
XFILLER_0_48_338 VGND VGND VPWR VPWR sky130_fd_sc_hd__fill_2
XFILLER_0_48_349 VGND VGND VPWR VPWR sky130_fd_sc_hd__decap_3
XFILLER_0_63_319 VGND VGND VPWR VPWR sky130_fd_sc_hd__decap_8
X_2986_ _0663_ VGND VGND VPWR VPWR _0110_ sky130_fd_sc_hd__clkbuf_1
XFILLER_0_8_457 VPWR VGND VPWR VGND sky130_ef_sc_hd__decap_12
XFILLER_0_44_533 VGND VGND VPWR VPWR sky130_fd_sc_hd__fill_1
X_4725_ clknet_leaf_37_clk _0423_ net10 VGND VGND VPWR VPWR tree_instances\[14\].u_tree.pipeline_current_node\[0\]\[3\]
+ sky130_fd_sc_hd__dfrtp_1
X_4656_ clknet_leaf_12_clk _0361_ tree_instances\[0\].u_tree.rst_n VGND VGND VPWR
+ VPWR tree_instances\[11\].u_tree.pipeline_current_node\[0\]\[4\] sky130_fd_sc_hd__dfrtp_1
X_3607_ _1128_ VGND VGND VPWR VPWR _0266_ sky130_fd_sc_hd__clkbuf_1
X_4587_ clknet_leaf_13_clk _0307_ net12 VGND VGND VPWR VPWR tree_instances\[8\].u_tree.pipeline_frame_id\[0\]\[4\]
+ sky130_fd_sc_hd__dfrtp_1
XFILLER_0_12_452 VPWR VGND VPWR VGND sky130_ef_sc_hd__decap_12
X_3538_ _1082_ VGND VGND VPWR VPWR _0243_ sky130_fd_sc_hd__clkbuf_1
XANTENNA_clkbuf_leaf_51_clk_A clknet_3_5__leaf_clk VGND VGND VPWR VPWR sky130_fd_sc_hd__diode_2
X_3469_ _1038_ VGND VGND VPWR VPWR _0218_ sky130_fd_sc_hd__clkbuf_1
XANTENNA_clkbuf_leaf_66_clk_A clknet_3_1__leaf_clk VGND VGND VPWR VPWR sky130_fd_sc_hd__diode_2
XANTENNA__3418__A1 _0673_ VGND VGND VPWR VPWR sky130_fd_sc_hd__diode_2
XFILLER_0_66_102 VPWR VGND VPWR VGND sky130_ef_sc_hd__decap_12
XTAP_TAPCELL_ROW_55_756 VGND VPWR sky130_fd_sc_hd__tapvpwrvgnd_1
XANTENNA__4437__RESET_B net13 VGND VGND VPWR VPWR sky130_fd_sc_hd__diode_2
XFILLER_0_94_477 VPWR VGND VPWR VGND sky130_ef_sc_hd__decap_12
XFILLER_0_66_146 VGND VGND VPWR VPWR sky130_fd_sc_hd__fill_2
XFILLER_0_62_341 VGND VGND VPWR VPWR sky130_fd_sc_hd__fill_1
XFILLER_0_50_525 VGND VGND VPWR VPWR sky130_fd_sc_hd__fill_2
XANTENNA_clkbuf_leaf_19_clk_A clknet_3_3__leaf_clk VGND VGND VPWR VPWR sky130_fd_sc_hd__diode_2
XANTENNA__4860__RESET_B net10 VGND VGND VPWR VPWR sky130_fd_sc_hd__diode_2
XFILLER_0_70_15 VGND VGND VPWR VPWR sky130_fd_sc_hd__decap_4
XFILLER_0_57_135 VPWR VGND VPWR VGND sky130_ef_sc_hd__decap_12
XFILLER_0_57_113 VGND VGND VPWR VPWR sky130_fd_sc_hd__decap_8
X_2840_ tree_instances\[20\].u_tree.pipeline_current_node\[0\]\[1\] VGND VGND VPWR
+ VPWR _2143_ sky130_fd_sc_hd__clkbuf_1
XFILLER_0_38_360 VGND VGND VPWR VPWR sky130_fd_sc_hd__decap_4
X_2771_ _1660_ VGND VGND VPWR VPWR _2079_ sky130_fd_sc_hd__clkbuf_1
XFILLER_0_5_449 VPWR VGND VPWR VGND sky130_ef_sc_hd__decap_12
X_4510_ clknet_leaf_61_clk _0241_ tree_instances\[0\].u_tree.rst_n VGND VGND VPWR
+ VPWR tree_instances\[5\].u_tree.pipeline_frame_id\[0\]\[1\] sky130_fd_sc_hd__dfrtp_1
XFILLER_0_41_503 VGND VGND VPWR VPWR sky130_fd_sc_hd__fill_1
XFILLER_0_53_385 VGND VGND VPWR VPWR sky130_fd_sc_hd__decap_6
X_4441_ clknet_leaf_56_clk _0187_ net13 VGND VGND VPWR VPWR tree_instances\[2\].u_tree.ready_for_next
+ sky130_fd_sc_hd__dfstp_1
XPHY_EDGE_ROW_9_Right_9 VGND VGND VPWR VPWR sky130_fd_sc_hd__decap_3
X_4372_ clknet_leaf_14_clk _0040_ net12 VGND VGND VPWR VPWR tree_instances\[8\].u_tree.tree_state\[2\]
+ sky130_fd_sc_hd__dfrtp_1
X_3323_ _0950_ VGND VGND VPWR VPWR _0160_ sky130_fd_sc_hd__clkbuf_1
XFILLER_0_0_165 VGND VGND VPWR VPWR sky130_fd_sc_hd__decap_3
X_3254_ _0914_ VGND VGND VPWR VPWR _0127_ sky130_fd_sc_hd__clkbuf_1
X_2205_ _1584_ tree_instances\[9\].u_tree.pipeline_current_node\[0\]\[0\] VGND VGND
+ VPWR VPWR _1585_ sky130_fd_sc_hd__or2_1
XFILLER_0_28_72 VPWR VGND VPWR VGND sky130_ef_sc_hd__decap_12
X_3185_ _0650_ tree_instances\[8\].u_tree.frame_id_out\[1\] VGND VGND VPWR VPWR _0857_
+ sky130_fd_sc_hd__nor2_1
XANTENNA__4530__RESET_B net11 VGND VGND VPWR VPWR sky130_fd_sc_hd__diode_2
XFILLER_0_76_433 VPWR VGND VPWR VGND sky130_ef_sc_hd__decap_12
XFILLER_0_44_93 VGND VGND VPWR VPWR sky130_fd_sc_hd__decap_3
XTAP_TAPCELL_ROW_52_726 VGND VPWR sky130_fd_sc_hd__tapvpwrvgnd_1
XFILLER_0_29_371 VGND VGND VPWR VPWR sky130_fd_sc_hd__fill_1
XFILLER_0_91_447 VGND VGND VPWR VPWR sky130_fd_sc_hd__fill_1
XFILLER_0_29_393 VGND VGND VPWR VPWR sky130_fd_sc_hd__fill_2
X_2969_ current_voting_frame\[1\] VGND VGND VPWR VPWR _0650_ sky130_fd_sc_hd__buf_2
XFILLER_0_8_298 VGND VGND VPWR VPWR sky130_fd_sc_hd__decap_8
X_4708_ clknet_leaf_4_clk _0411_ net9 VGND VGND VPWR VPWR tree_instances\[13\].u_tree.pipeline_frame_id\[0\]\[3\]
+ sky130_fd_sc_hd__dfrtp_1
XFILLER_0_44_363 VGND VGND VPWR VPWR sky130_fd_sc_hd__fill_1
XFILLER_0_44_385 VGND VGND VPWR VPWR sky130_fd_sc_hd__fill_2
XFILLER_0_32_569 VGND VGND VPWR VPWR sky130_fd_sc_hd__decap_4
X_4639_ clknet_leaf_4_clk _0349_ tree_instances\[0\].u_tree.rst_n VGND VGND VPWR VPWR
+ tree_instances\[10\].u_tree.frame_id_out\[0\] sky130_fd_sc_hd__dfrtp_1
XANTENNA__3734__C _0610_ VGND VGND VPWR VPWR sky130_fd_sc_hd__diode_2
XANTENNA__4689__RESET_B net11 VGND VGND VPWR VPWR sky130_fd_sc_hd__diode_2
XTAP_TAPCELL_ROW_68_892 VGND VPWR sky130_fd_sc_hd__tapvpwrvgnd_1
XFILLER_0_79_260 VPWR VGND VPWR VGND sky130_ef_sc_hd__decap_12
XFILLER_0_79_293 VGND VGND VPWR VPWR sky130_fd_sc_hd__decap_4
XFILLER_0_39_113 VGND VGND VPWR VPWR sky130_fd_sc_hd__decap_8
XFILLER_0_39_124 VPWR VGND VPWR VGND sky130_ef_sc_hd__decap_12
XFILLER_0_82_436 VPWR VGND VPWR VGND sky130_ef_sc_hd__decap_12
XFILLER_0_54_105 VGND VGND VPWR VPWR sky130_fd_sc_hd__fill_2
XFILLER_0_40_29 VGND VGND VPWR VPWR sky130_fd_sc_hd__fill_2
XFILLER_0_62_182 VGND VGND VPWR VPWR sky130_fd_sc_hd__fill_2
XFILLER_0_2_419 VGND VGND VPWR VPWR sky130_fd_sc_hd__fill_1
XTAP_TAPCELL_ROW_91_1121 VGND VPWR sky130_fd_sc_hd__tapvpwrvgnd_1
XFILLER_0_4_29 VPWR VGND VPWR VGND sky130_ef_sc_hd__decap_12
XFILLER_0_65_48 VGND VGND VPWR VPWR sky130_fd_sc_hd__decap_4
XFILLER_0_65_26 VGND VGND VPWR VPWR sky130_fd_sc_hd__fill_2
XANTENNA__4359__RESET_B net12 VGND VGND VPWR VPWR sky130_fd_sc_hd__diode_2
XTAP_TAPCELL_ROW_89_1094 VGND VPWR sky130_fd_sc_hd__tapvpwrvgnd_1
XFILLER_0_77_219 VGND VGND VPWR VPWR sky130_fd_sc_hd__decap_4
XFILLER_0_73_403 VGND VGND VPWR VPWR sky130_fd_sc_hd__fill_1
XFILLER_0_58_477 VGND VGND VPWR VPWR sky130_fd_sc_hd__decap_8
X_3941_ _1770_ _1330_ _0034_ tree_instances\[5\].u_tree.pipeline_valid\[0\] VGND VGND
+ VPWR VPWR _0398_ sky130_fd_sc_hd__o2bb2a_1
XANTENNA__3802__A1 _1165_ VGND VGND VPWR VPWR sky130_fd_sc_hd__diode_2
XFILLER_0_85_285 VGND VGND VPWR VPWR sky130_fd_sc_hd__fill_1
X_3872_ tree_instances\[14\].u_tree.pipeline_current_node\[0\]\[2\] VGND VGND VPWR
+ VPWR _1282_ sky130_fd_sc_hd__clkbuf_1
XFILLER_0_45_105 VGND VGND VPWR VPWR sky130_fd_sc_hd__decap_6
X_2823_ tree_instances\[0\].u_tree.pipeline_current_node\[0\]\[1\] VGND VGND VPWR
+ VPWR _2126_ sky130_fd_sc_hd__clkbuf_1
XFILLER_0_73_458 VGND VGND VPWR VPWR sky130_fd_sc_hd__fill_2
XFILLER_0_5_202 VGND VGND VPWR VPWR sky130_fd_sc_hd__decap_6
XFILLER_0_45_149 VGND VGND VPWR VPWR sky130_fd_sc_hd__decap_6
X_2754_ _2061_ VGND VGND VPWR VPWR _2065_ sky130_fd_sc_hd__clkbuf_1
XFILLER_0_14_525 VGND VGND VPWR VPWR sky130_fd_sc_hd__decap_6
XFILLER_0_5_279 VGND VGND VPWR VPWR sky130_fd_sc_hd__fill_1
XFILLER_0_5_268 VGND VGND VPWR VPWR sky130_fd_sc_hd__decap_6
XFILLER_0_53_193 VGND VGND VPWR VPWR sky130_fd_sc_hd__fill_2
XFILLER_0_14_569 VGND VGND VPWR VPWR sky130_fd_sc_hd__decap_4
X_2685_ tree_instances\[2\].u_tree.prediction_valid _1891_ VGND VGND VPWR VPWR _2005_
+ sky130_fd_sc_hd__and2b_1
X_4424_ clknet_leaf_55_clk _0170_ tree_instances\[0\].u_tree.rst_n VGND VGND VPWR
+ VPWR tree_instances\[2\].u_tree.pipeline_current_node\[0\]\[2\] sky130_fd_sc_hd__dfrtp_1
X_4355_ clknet_leaf_28_clk _0115_ net13 VGND VGND VPWR VPWR tree_instances\[0\].u_tree.frame_id_in\[4\]
+ sky130_fd_sc_hd__dfrtp_4
XFILLER_0_1_485 VPWR VGND VPWR VGND sky130_ef_sc_hd__decap_12
X_3306_ _0576_ _0936_ VGND VGND VPWR VPWR _0942_ sky130_fd_sc_hd__and2_1
X_4286_ _1439_ _1524_ VGND VGND VPWR VPWR _1526_ sky130_fd_sc_hd__and2_1
XANTENNA__4782__RESET_B net13 VGND VGND VPWR VPWR sky130_fd_sc_hd__diode_2
X_3237_ complete_votes\[4\] _0885_ _0896_ _0904_ VGND VGND VPWR VPWR _0120_ sky130_fd_sc_hd__o31ai_1
XANTENNA__4711__RESET_B net9 VGND VGND VPWR VPWR sky130_fd_sc_hd__diode_2
X_3168_ _0654_ tree_instances\[11\].u_tree.frame_id_out\[2\] VGND VGND VPWR VPWR _0840_
+ sky130_fd_sc_hd__nor2_1
XFILLER_0_96_517 VPWR VGND VPWR VGND sky130_ef_sc_hd__decap_12
X_3099_ _0686_ tree_instances\[1\].u_tree.frame_id_out\[1\] tree_instances\[1\].u_tree.prediction_valid
+ _0767_ _0770_ VGND VGND VPWR VPWR _0771_ sky130_fd_sc_hd__o2111a_1
XTAP_TAPCELL_ROW_65_862 VGND VPWR sky130_fd_sc_hd__tapvpwrvgnd_1
XTAP_TAPCELL_ROW_37_575 VGND VPWR sky130_fd_sc_hd__tapvpwrvgnd_1
XFILLER_0_76_241 VGND VGND VPWR VPWR sky130_fd_sc_hd__fill_2
XFILLER_0_71_91 VGND VGND VPWR VPWR sky130_fd_sc_hd__decap_8
XFILLER_0_9_541 VPWR VGND VPWR VGND sky130_ef_sc_hd__decap_12
XFILLER_0_64_458 VPWR VGND VPWR VGND sky130_ef_sc_hd__decap_12
XFILLER_0_36_138 VGND VGND VPWR VPWR sky130_fd_sc_hd__fill_2
XFILLER_0_32_344 VGND VGND VPWR VPWR sky130_fd_sc_hd__fill_2
XFILLER_0_32_355 VGND VGND VPWR VPWR sky130_fd_sc_hd__decap_8
XFILLER_0_32_377 VGND VGND VPWR VPWR sky130_fd_sc_hd__decap_8
XANTENNA__4452__RESET_B net9 VGND VGND VPWR VPWR sky130_fd_sc_hd__diode_2
XFILLER_0_59_208 VPWR VGND VPWR VGND sky130_ef_sc_hd__decap_12
XFILLER_0_95_561 VGND VGND VPWR VPWR sky130_fd_sc_hd__decap_6
XFILLER_0_51_39 VGND VGND VPWR VPWR sky130_fd_sc_hd__decap_8
XFILLER_0_82_266 VGND VGND VPWR VPWR sky130_fd_sc_hd__decap_8
XFILLER_0_82_299 VGND VGND VPWR VPWR sky130_fd_sc_hd__fill_2
Xclkload26 clknet_leaf_15_clk VGND VGND VPWR VPWR clkload26/Y sky130_fd_sc_hd__inv_6
XFILLER_0_23_311 VGND VGND VPWR VPWR sky130_fd_sc_hd__fill_2
XFILLER_0_23_333 VGND VGND VPWR VPWR sky130_fd_sc_hd__decap_3
Xclkload15 clknet_leaf_61_clk VGND VGND VPWR VPWR clkload15/Y sky130_fd_sc_hd__bufinv_16
XANTENNA__4644__SET_B tree_instances\[0\].u_tree.rst_n VGND VGND VPWR VPWR sky130_fd_sc_hd__diode_2
Xclkload59 clknet_leaf_33_clk VGND VGND VPWR VPWR clkload59/Y sky130_fd_sc_hd__bufinv_16
XFILLER_0_2_227 VPWR VGND VPWR VGND sky130_ef_sc_hd__decap_12
Xclkload48 clknet_leaf_52_clk VGND VGND VPWR VPWR clkload48/Y sky130_fd_sc_hd__inv_6
XFILLER_0_23_366 VPWR VGND VPWR VGND sky130_ef_sc_hd__decap_12
Xclkload37 clknet_leaf_45_clk VGND VGND VPWR VPWR clkload37/Y sky130_fd_sc_hd__clkinv_2
XFILLER_0_50_141 VPWR VGND VPWR VGND sky130_ef_sc_hd__decap_12
XFILLER_0_11_517 VPWR VGND VPWR VGND sky130_ef_sc_hd__decap_12
X_2470_ _1820_ VGND VGND VPWR VPWR _1821_ sky130_fd_sc_hd__clkbuf_1
XFILLER_0_23_388 VGND VGND VPWR VPWR sky130_fd_sc_hd__fill_2
XFILLER_0_50_174 VGND VGND VPWR VPWR sky130_fd_sc_hd__fill_1
XFILLER_0_76_36 VGND VGND VPWR VPWR sky130_fd_sc_hd__fill_1
X_4140_ _1442_ _1444_ VGND VGND VPWR VPWR _1445_ sky130_fd_sc_hd__and2_1
X_4071_ _0016_ VGND VGND VPWR VPWR _1397_ sky130_fd_sc_hd__inv_2
XFILLER_0_92_35 VGND VGND VPWR VPWR sky130_fd_sc_hd__fill_1
XTAP_TAPCELL_ROW_79_998 VGND VPWR sky130_fd_sc_hd__tapvpwrvgnd_1
X_3022_ _0646_ VGND VGND VPWR VPWR _0694_ sky130_fd_sc_hd__clkbuf_4
XFILLER_0_92_57 VGND VGND VPWR VPWR sky130_fd_sc_hd__decap_8
XTAP_TAPCELL_ROW_62_832 VGND VPWR sky130_fd_sc_hd__tapvpwrvgnd_1
XANTENNA__3236__C1 _0645_ VGND VGND VPWR VPWR sky130_fd_sc_hd__diode_2
XFILLER_0_73_200 VGND VGND VPWR VPWR sky130_fd_sc_hd__fill_2
XTAP_TAPCELL_ROW_34_545 VGND VPWR sky130_fd_sc_hd__tapvpwrvgnd_1
X_3924_ tree_instances\[15\].u_tree.pipeline_current_node\[0\]\[1\] VGND VGND VPWR
+ VPWR _1314_ sky130_fd_sc_hd__clkbuf_1
XFILLER_0_73_233 VGND VGND VPWR VPWR sky130_fd_sc_hd__fill_2
XFILLER_0_18_149 VGND VGND VPWR VPWR sky130_fd_sc_hd__decap_3
XFILLER_0_73_255 VGND VGND VPWR VPWR sky130_fd_sc_hd__fill_1
Xclkload9 clknet_leaf_68_clk VGND VGND VPWR VPWR clkload9/Y sky130_fd_sc_hd__inv_6
XFILLER_0_6_533 VPWR VGND VPWR VGND sky130_ef_sc_hd__decap_12
XFILLER_0_41_83 VGND VGND VPWR VPWR sky130_fd_sc_hd__fill_2
X_3855_ _1271_ VGND VGND VPWR VPWR _0371_ sky130_fd_sc_hd__clkbuf_1
XFILLER_0_14_300 VGND VGND VPWR VPWR sky130_fd_sc_hd__decap_8
X_2806_ _1848_ VGND VGND VPWR VPWR _2110_ sky130_fd_sc_hd__clkbuf_1
X_3786_ _0588_ _1232_ VGND VGND VPWR VPWR _1236_ sky130_fd_sc_hd__and2_1
XFILLER_0_14_355 VGND VGND VPWR VPWR sky130_fd_sc_hd__decap_8
X_2737_ _2047_ VGND VGND VPWR VPWR _2048_ sky130_fd_sc_hd__clkbuf_1
X_2668_ _1987_ VGND VGND VPWR VPWR _1990_ sky130_fd_sc_hd__clkbuf_1
XFILLER_0_14_377 VPWR VGND VPWR VGND sky130_ef_sc_hd__decap_12
X_4407_ clknet_leaf_32_clk _0154_ net13 VGND VGND VPWR VPWR tree_instances\[1\].u_tree.pipeline_current_node\[0\]\[7\]
+ sky130_fd_sc_hd__dfrtp_1
XFILLER_0_1_260 VGND VGND VPWR VPWR sky130_fd_sc_hd__fill_2
X_2599_ _1928_ _1930_ VGND VGND VPWR VPWR _1931_ sky130_fd_sc_hd__nand2_1
X_4338_ clknet_leaf_50_clk _0019_ net10 VGND VGND VPWR VPWR tree_instances\[18\].u_tree.tree_state\[1\]
+ sky130_fd_sc_hd__dfrtp_1
XANTENNA__2197__A _1574_ VGND VGND VPWR VPWR sky130_fd_sc_hd__diode_2
XANTENNA__4267__A1 tree_instances\[0\].u_tree.frame_id_in\[4\] VGND VGND VPWR VPWR
+ sky130_fd_sc_hd__diode_2
X_4269_ tree_instances\[19\].u_tree.frame_id_out\[0\] tree_instances\[19\].u_tree.pipeline_frame_id\[0\]\[0\]
+ _1970_ VGND VGND VPWR VPWR _1517_ sky130_fd_sc_hd__mux2_1
XFILLER_0_77_561 VPWR VGND VPWR VGND sky130_ef_sc_hd__decap_12
XFILLER_0_92_531 VGND VGND VPWR VPWR sky130_fd_sc_hd__fill_1
XFILLER_0_64_233 VPWR VGND VPWR VGND sky130_ef_sc_hd__decap_12
XANTENNA__3242__A2 _0649_ VGND VGND VPWR VPWR sky130_fd_sc_hd__diode_2
XFILLER_0_9_393 VPWR VGND VPWR VGND sky130_ef_sc_hd__decap_12
XFILLER_0_9_371 VPWR VGND VPWR VGND sky130_ef_sc_hd__decap_12
XFILLER_0_24_108 VPWR VGND VPWR VGND sky130_ef_sc_hd__decap_12
XANTENNA__4717__SET_B tree_instances\[0\].u_tree.rst_n VGND VGND VPWR VPWR sky130_fd_sc_hd__diode_2
Xrst_buf net16 VGND VGND VPWR VPWR tree_instances\[0\].u_tree.rst_n sky130_fd_sc_hd__clkbuf_16
XFILLER_0_32_141 VGND VGND VPWR VPWR sky130_fd_sc_hd__fill_2
XFILLER_0_32_163 VPWR VGND VPWR VGND sky130_ef_sc_hd__decap_12
XFILLER_0_20_325 VGND VGND VPWR VPWR sky130_fd_sc_hd__fill_1
XANTENNA__4633__RESET_B tree_instances\[0\].u_tree.rst_n VGND VGND VPWR VPWR sky130_fd_sc_hd__diode_2
XTAP_TAPCELL_ROW_76_968 VGND VPWR sky130_fd_sc_hd__tapvpwrvgnd_1
XTAP_TAPCELL_ROW_86_1064 VGND VPWR sky130_fd_sc_hd__tapvpwrvgnd_1
XFILLER_0_95_391 VGND VGND VPWR VPWR sky130_fd_sc_hd__fill_1
XTAP_TAPCELL_ROW_31_515 VGND VPWR sky130_fd_sc_hd__tapvpwrvgnd_1
XFILLER_0_28_469 VGND VGND VPWR VPWR sky130_fd_sc_hd__decap_4
XFILLER_0_70_225 VPWR VGND VPWR VGND sky130_ef_sc_hd__decap_12
X_3640_ _1150_ _1139_ VGND VGND VPWR VPWR _1151_ sky130_fd_sc_hd__and2_1
XFILLER_0_3_503 VGND VGND VPWR VPWR sky130_fd_sc_hd__fill_1
X_3571_ _1103_ VGND VGND VPWR VPWR _1104_ sky130_fd_sc_hd__clkbuf_1
X_2522_ _1866_ VGND VGND VPWR VPWR _1867_ sky130_fd_sc_hd__clkbuf_1
XFILLER_0_51_461 VGND VGND VPWR VPWR sky130_fd_sc_hd__fill_1
XFILLER_0_87_57 VGND VGND VPWR VPWR sky130_fd_sc_hd__fill_1
XANTENNA_clkbuf_3_0__f_clk_A clknet_0_clk VGND VGND VPWR VPWR sky130_fd_sc_hd__diode_2
X_2453_ tree_instances\[10\].u_tree.tree_state\[2\] _1805_ tree_instances\[10\].u_tree.tree_state\[1\]
+ VGND VGND VPWR VPWR _0083_ sky130_fd_sc_hd__a21o_1
X_2384_ tree_instances\[14\].u_tree.pipeline_current_node\[0\]\[8\] _1744_ VGND VGND
+ VPWR VPWR _1745_ sky130_fd_sc_hd__nor2_1
X_4123_ _1428_ VGND VGND VPWR VPWR _1429_ sky130_fd_sc_hd__clkbuf_1
X_4054_ tree_instances\[15\].u_tree.pipeline_frame_id\[0\]\[3\] _1192_ _0014_ VGND
+ VGND VPWR VPWR _1389_ sky130_fd_sc_hd__mux2_1
X_3005_ _0678_ _0677_ VGND VGND VPWR VPWR _0679_ sky130_fd_sc_hd__or2_1
XFILLER_0_36_83 VGND VGND VPWR VPWR sky130_fd_sc_hd__fill_1
XFILLER_0_78_369 VPWR VGND VPWR VGND sky130_ef_sc_hd__decap_12
XTAP_TAPCELL_ROW_47_681 VGND VPWR sky130_fd_sc_hd__tapvpwrvgnd_1
XFILLER_0_59_561 VPWR VGND VPWR VGND sky130_ef_sc_hd__decap_12
XTAP_TAPCELL_ROW_19_394 VGND VPWR sky130_fd_sc_hd__tapvpwrvgnd_1
X_3907_ tree_instances\[12\].u_tree.pipeline_frame_id\[0\]\[2\] _1165_ _0008_ VGND
+ VGND VPWR VPWR _1306_ sky130_fd_sc_hd__mux2_1
X_4887_ clknet_leaf_27_clk _0559_ net11 VGND VGND VPWR VPWR tree_instances\[20\].u_tree.pipeline_frame_id\[0\]\[3\]
+ sky130_fd_sc_hd__dfrtp_1
XFILLER_0_46_277 VGND VGND VPWR VPWR sky130_fd_sc_hd__decap_4
X_3838_ _2038_ _1255_ VGND VGND VPWR VPWR _1263_ sky130_fd_sc_hd__and2_1
XFILLER_0_61_225 VGND VGND VPWR VPWR sky130_fd_sc_hd__fill_2
XFILLER_0_34_439 VGND VGND VPWR VPWR sky130_fd_sc_hd__fill_1
XFILLER_0_14_152 VGND VGND VPWR VPWR sky130_fd_sc_hd__fill_1
X_3769_ _1226_ VGND VGND VPWR VPWR _0330_ sky130_fd_sc_hd__clkbuf_1
XANTENNA__3160__A1 _0691_ VGND VGND VPWR VPWR sky130_fd_sc_hd__diode_2
XTAP_TAPCELL_ROW_73_938 VGND VPWR sky130_fd_sc_hd__tapvpwrvgnd_1
XFILLER_0_77_391 VGND VGND VPWR VPWR sky130_fd_sc_hd__fill_1
XFILLER_0_92_361 VGND VGND VPWR VPWR sky130_fd_sc_hd__decap_3
XFILLER_0_37_244 VGND VGND VPWR VPWR sky130_fd_sc_hd__decap_8
XFILLER_0_25_417 VGND VGND VPWR VPWR sky130_fd_sc_hd__decap_6
XANTENNA__4885__RESET_B net12 VGND VGND VPWR VPWR sky130_fd_sc_hd__diode_2
XFILLER_0_0_517 VPWR VGND VPWR VGND sky130_ef_sc_hd__decap_12
XANTENNA__4814__RESET_B net13 VGND VGND VPWR VPWR sky130_fd_sc_hd__diode_2
XPHY_EDGE_ROW_29_Left_126 VGND VGND VPWR VPWR sky130_fd_sc_hd__decap_3
XFILLER_0_57_38 VPWR VGND VPWR VGND sky130_ef_sc_hd__decap_12
XANTENNA__3151__A1 _0647_ VGND VGND VPWR VPWR sky130_fd_sc_hd__diode_2
XANTENNA__3151__B2 _0658_ VGND VGND VPWR VPWR sky130_fd_sc_hd__diode_2
XPHY_EDGE_ROW_38_Left_135 VGND VGND VPWR VPWR sky130_fd_sc_hd__decap_3
X_4810_ clknet_leaf_45_clk _0497_ net11 VGND VGND VPWR VPWR tree_instances\[17\].u_tree.frame_id_out\[0\]
+ sky130_fd_sc_hd__dfrtp_1
XTAP_TAPCELL_ROW_16_364 VGND VPWR sky130_fd_sc_hd__tapvpwrvgnd_1
XFILLER_0_28_233 VGND VGND VPWR VPWR sky130_fd_sc_hd__fill_2
XTAP_TAPCELL_ROW_44_651 VGND VPWR sky130_fd_sc_hd__tapvpwrvgnd_1
XFILLER_0_90_309 VGND VGND VPWR VPWR sky130_fd_sc_hd__fill_2
X_4741_ clknet_leaf_39_clk _0439_ net10 VGND VGND VPWR VPWR tree_instances\[14\].u_tree.ready_for_next
+ sky130_fd_sc_hd__dfstp_1
XFILLER_0_22_63 VGND VGND VPWR VPWR sky130_fd_sc_hd__fill_1
XFILLER_0_28_288 VGND VGND VPWR VPWR sky130_fd_sc_hd__fill_1
X_4672_ clknet_leaf_10_clk _0087_ tree_instances\[0\].u_tree.rst_n VGND VGND VPWR
+ VPWR tree_instances\[11\].u_tree.prediction_valid sky130_fd_sc_hd__dfrtp_1
XFILLER_0_71_556 VGND VGND VPWR VPWR sky130_fd_sc_hd__decap_4
X_3623_ _1136_ VGND VGND VPWR VPWR _1137_ sky130_fd_sc_hd__clkbuf_1
XANTENNA__4555__RESET_B tree_instances\[0\].u_tree.rst_n VGND VGND VPWR VPWR sky130_fd_sc_hd__diode_2
X_3554_ _1597_ _1090_ _0004_ tree_instances\[10\].u_tree.pipeline_valid\[0\] VGND
+ VGND VPWR VPWR _0251_ sky130_fd_sc_hd__o2bb2a_1
X_2505_ _1848_ _1850_ VGND VGND VPWR VPWR _1851_ sky130_fd_sc_hd__nor2_1
X_3485_ _1046_ VGND VGND VPWR VPWR _0226_ sky130_fd_sc_hd__clkbuf_1
XPHY_EDGE_ROW_47_Left_144 VGND VGND VPWR VPWR sky130_fd_sc_hd__decap_3
XANTENNA__4763__SET_B net10 VGND VGND VPWR VPWR sky130_fd_sc_hd__diode_2
X_2436_ _1788_ _1789_ VGND VGND VPWR VPWR _1790_ sky130_fd_sc_hd__nor2_1
XFILLER_0_37_3 VGND VGND VPWR VPWR sky130_fd_sc_hd__decap_8
X_2367_ tree_instances\[16\].u_tree.tree_state\[3\] VGND VGND VPWR VPWR _1729_ sky130_fd_sc_hd__buf_2
X_2298_ tree_instances\[8\].u_tree.tree_state\[3\] VGND VGND VPWR VPWR _1668_ sky130_fd_sc_hd__buf_2
X_4106_ tree_instances\[16\].u_tree.frame_id_out\[2\] tree_instances\[16\].u_tree.pipeline_frame_id\[0\]\[2\]
+ _1729_ VGND VGND VPWR VPWR _1416_ sky130_fd_sc_hd__mux2_1
X_4037_ _1380_ VGND VGND VPWR VPWR _0444_ sky130_fd_sc_hd__clkbuf_1
XPHY_EDGE_ROW_56_Left_153 VGND VGND VPWR VPWR sky130_fd_sc_hd__decap_3
XTAP_TAPCELL_ROW_70_908 VGND VPWR sky130_fd_sc_hd__tapvpwrvgnd_1
XFILLER_0_59_391 VGND VGND VPWR VPWR sky130_fd_sc_hd__fill_1
XFILLER_0_19_211 VPWR VGND VPWR VGND sky130_ef_sc_hd__decap_12
XFILLER_0_93_169 VGND VGND VPWR VPWR sky130_fd_sc_hd__fill_1
XFILLER_0_74_350 VPWR VGND VPWR VGND sky130_ef_sc_hd__decap_12
XFILLER_0_62_567 VGND VGND VPWR VPWR sky130_fd_sc_hd__decap_6
XPHY_EDGE_ROW_65_Left_162 VGND VGND VPWR VPWR sky130_fd_sc_hd__decap_3
XFILLER_0_15_483 VGND VGND VPWR VPWR sky130_fd_sc_hd__fill_2
XFILLER_0_42_280 VPWR VGND VPWR VGND sky130_ef_sc_hd__decap_12
XFILLER_0_30_453 VPWR VGND VPWR VGND sky130_ef_sc_hd__decap_12
XPHY_EDGE_ROW_74_Left_171 VGND VGND VPWR VPWR sky130_fd_sc_hd__decap_3
XFILLER_0_69_100 VPWR VGND VPWR VGND sky130_ef_sc_hd__decap_12
XTAP_TAPCELL_ROW_58_787 VGND VPWR sky130_fd_sc_hd__tapvpwrvgnd_1
XTAP_TAPCELL_ROW_83_1034 VGND VPWR sky130_fd_sc_hd__tapvpwrvgnd_1
XFILLER_0_57_317 VPWR VGND VPWR VGND sky130_ef_sc_hd__decap_12
XFILLER_0_38_520 VGND VGND VPWR VPWR sky130_fd_sc_hd__fill_1
XTAP_TAPCELL_ROW_41_621 VGND VPWR sky130_fd_sc_hd__tapvpwrvgnd_1
XFILLER_0_65_383 VGND VGND VPWR VPWR sky130_fd_sc_hd__decap_8
XFILLER_0_65_361 VGND VGND VPWR VPWR sky130_fd_sc_hd__decap_3
XTAP_TAPCELL_ROW_13_334 VGND VPWR sky130_fd_sc_hd__tapvpwrvgnd_1
XFILLER_0_80_342 VGND VGND VPWR VPWR sky130_fd_sc_hd__fill_1
XPHY_EDGE_ROW_83_Left_180 VGND VGND VPWR VPWR sky130_fd_sc_hd__decap_3
XTAP_TAPCELL_ROW_94_1152 VGND VPWR sky130_fd_sc_hd__tapvpwrvgnd_1
XFILLER_0_68_59 VGND VGND VPWR VPWR sky130_fd_sc_hd__fill_2
XFILLER_0_68_37 VGND VGND VPWR VPWR sky130_fd_sc_hd__fill_2
XANTENNA__3372__A1 _0665_ VGND VGND VPWR VPWR sky130_fd_sc_hd__diode_2
X_3270_ _0922_ VGND VGND VPWR VPWR _0135_ sky130_fd_sc_hd__clkbuf_1
X_2221_ tree_instances\[11\].u_tree.pipeline_current_node\[0\]\[8\] VGND VGND VPWR
+ VPWR _1598_ sky130_fd_sc_hd__inv_2
XFILLER_0_88_475 VGND VGND VPWR VPWR sky130_fd_sc_hd__fill_1
XFILLER_0_75_125 VPWR VGND VPWR VGND sky130_ef_sc_hd__decap_12
XFILLER_0_33_51 VGND VGND VPWR VPWR sky130_fd_sc_hd__decap_4
XFILLER_0_75_169 VGND VGND VPWR VPWR sky130_fd_sc_hd__fill_2
X_4724_ clknet_leaf_35_clk _0422_ net10 VGND VGND VPWR VPWR tree_instances\[14\].u_tree.pipeline_current_node\[0\]\[2\]
+ sky130_fd_sc_hd__dfrtp_1
X_2985_ _0662_ net6 _0645_ VGND VGND VPWR VPWR _0663_ sky130_fd_sc_hd__mux2_1
XFILLER_0_8_469 VGND VGND VPWR VPWR sky130_fd_sc_hd__decap_6
XFILLER_0_44_501 VGND VGND VPWR VPWR sky130_fd_sc_hd__fill_2
XFILLER_0_56_361 VGND VGND VPWR VPWR sky130_fd_sc_hd__decap_3
XANTENNA__4736__RESET_B net11 VGND VGND VPWR VPWR sky130_fd_sc_hd__diode_2
XFILLER_0_44_567 VGND VGND VPWR VPWR sky130_fd_sc_hd__decap_6
X_4655_ clknet_leaf_13_clk _0360_ net12 VGND VGND VPWR VPWR tree_instances\[11\].u_tree.pipeline_current_node\[0\]\[3\]
+ sky130_fd_sc_hd__dfrtp_1
X_3606_ tree_instances\[6\].u_tree.pipeline_frame_id\[0\]\[4\] _0682_ _0036_ VGND
+ VGND VPWR VPWR _1128_ sky130_fd_sc_hd__mux2_1
X_4586_ clknet_leaf_9_clk _0306_ net12 VGND VGND VPWR VPWR tree_instances\[8\].u_tree.pipeline_frame_id\[0\]\[3\]
+ sky130_fd_sc_hd__dfrtp_1
XFILLER_0_12_431 VGND VGND VPWR VPWR sky130_fd_sc_hd__decap_6
X_3537_ tree_instances\[5\].u_tree.pipeline_frame_id\[0\]\[3\] _0925_ _0034_ VGND
+ VGND VPWR VPWR _1082_ sky130_fd_sc_hd__mux2_1
XFILLER_0_12_486 VPWR VGND VPWR VGND sky130_ef_sc_hd__decap_12
XFILLER_0_12_475 VGND VGND VPWR VPWR sky130_fd_sc_hd__fill_1
XFILLER_0_58_92 VGND VGND VPWR VPWR sky130_fd_sc_hd__fill_1
X_3468_ _2098_ _1028_ VGND VGND VPWR VPWR _1038_ sky130_fd_sc_hd__and2_1
X_3399_ _0997_ VGND VGND VPWR VPWR _0189_ sky130_fd_sc_hd__clkbuf_1
X_2419_ _1773_ VGND VGND VPWR VPWR _0073_ sky130_fd_sc_hd__clkbuf_1
XFILLER_0_79_442 VGND VGND VPWR VPWR sky130_fd_sc_hd__decap_3
XFILLER_0_39_306 VGND VGND VPWR VPWR sky130_fd_sc_hd__fill_2
XTAP_TAPCELL_ROW_55_757 VGND VPWR sky130_fd_sc_hd__tapvpwrvgnd_1
XFILLER_0_66_114 VPWR VGND VPWR VGND sky130_ef_sc_hd__decap_12
XFILLER_0_94_456 VPWR VGND VPWR VGND sky130_ef_sc_hd__decap_12
XFILLER_0_94_489 VPWR VGND VPWR VGND sky130_ef_sc_hd__decap_12
XFILLER_0_74_180 VPWR VGND VPWR VGND sky130_ef_sc_hd__decap_12
XANTENNA__4477__RESET_B net9 VGND VGND VPWR VPWR sky130_fd_sc_hd__diode_2
XTAP_TAPCELL_ROW_10_304 VGND VPWR sky130_fd_sc_hd__tapvpwrvgnd_1
XANTENNA__4406__RESET_B net13 VGND VGND VPWR VPWR sky130_fd_sc_hd__diode_2
XFILLER_0_22_206 VPWR VGND VPWR VGND sky130_ef_sc_hd__decap_12
XFILLER_0_30_250 VGND VGND VPWR VPWR sky130_fd_sc_hd__fill_2
XFILLER_0_38_29 VPWR VGND VPWR VGND sky130_ef_sc_hd__decap_12
XFILLER_0_85_401 VGND VGND VPWR VPWR sky130_fd_sc_hd__fill_1
XFILLER_0_70_27 VGND VGND VPWR VPWR sky130_fd_sc_hd__fill_1
XFILLER_0_57_169 VGND VGND VPWR VPWR sky130_fd_sc_hd__decap_8
XFILLER_0_57_147 VPWR VGND VPWR VGND sky130_ef_sc_hd__decap_12
XTAP_TAPCELL_ROW_26_470 VGND VPWR sky130_fd_sc_hd__tapvpwrvgnd_1
XFILLER_0_38_350 VGND VGND VPWR VPWR sky130_fd_sc_hd__fill_1
XFILLER_0_72_139 VGND VGND VPWR VPWR sky130_fd_sc_hd__fill_1
X_2770_ _2071_ VGND VGND VPWR VPWR _2078_ sky130_fd_sc_hd__clkbuf_1
X_4440_ clknet_leaf_57_clk _0186_ net13 VGND VGND VPWR VPWR tree_instances\[2\].u_tree.frame_id_out\[4\]
+ sky130_fd_sc_hd__dfrtp_1
XFILLER_0_53_397 VGND VGND VPWR VPWR sky130_fd_sc_hd__fill_1
X_4371_ clknet_leaf_13_clk _0039_ net12 VGND VGND VPWR VPWR tree_instances\[8\].u_tree.tree_state\[1\]
+ sky130_fd_sc_hd__dfrtp_1
XFILLER_0_95_57 VPWR VGND VPWR VGND sky130_ef_sc_hd__decap_12
X_3322_ tree_instances\[1\].u_tree.pipeline_frame_id\[0\]\[4\] _0682_ _0024_ VGND
+ VGND VPWR VPWR _0950_ sky130_fd_sc_hd__mux2_1
X_3253_ _2128_ _0912_ VGND VGND VPWR VPWR _0914_ sky130_fd_sc_hd__and2_1
X_3184_ _0650_ tree_instances\[8\].u_tree.frame_id_out\[1\] VGND VGND VPWR VPWR _0856_
+ sky130_fd_sc_hd__and2_1
X_2204_ tree_instances\[9\].u_tree.pipeline_current_node\[0\]\[1\] VGND VGND VPWR
+ VPWR _1584_ sky130_fd_sc_hd__clkbuf_1
XFILLER_0_91_404 VPWR VGND VPWR VGND sky130_ef_sc_hd__decap_12
XFILLER_0_76_445 VPWR VGND VPWR VGND sky130_ef_sc_hd__decap_12
XFILLER_0_36_309 VPWR VGND VPWR VGND sky130_ef_sc_hd__decap_12
XTAP_TAPCELL_ROW_52_727 VGND VPWR sky130_fd_sc_hd__tapvpwrvgnd_1
XFILLER_0_60_60 VPWR VGND VPWR VGND sky130_ef_sc_hd__decap_12
XANTENNA__4570__RESET_B net9 VGND VGND VPWR VPWR sky130_fd_sc_hd__diode_2
XFILLER_0_44_342 VGND VGND VPWR VPWR sky130_fd_sc_hd__fill_2
X_2968_ net2 _0645_ _0649_ VGND VGND VPWR VPWR _0106_ sky130_fd_sc_hd__a21o_1
XFILLER_0_71_161 VGND VGND VPWR VPWR sky130_fd_sc_hd__decap_6
X_4707_ clknet_leaf_4_clk _0410_ net9 VGND VGND VPWR VPWR tree_instances\[13\].u_tree.pipeline_frame_id\[0\]\[2\]
+ sky130_fd_sc_hd__dfrtp_1
X_2899_ _0603_ _1828_ VGND VGND VPWR VPWR _0604_ sky130_fd_sc_hd__or2_1
X_4638_ clknet_leaf_3_clk _0348_ tree_instances\[0\].u_tree.rst_n VGND VGND VPWR VPWR
+ tree_instances\[10\].u_tree.pipeline_frame_id\[0\]\[4\] sky130_fd_sc_hd__dfrtp_1
XFILLER_0_8_83 VGND VGND VPWR VPWR sky130_fd_sc_hd__fill_1
XFILLER_0_12_250 VGND VGND VPWR VPWR sky130_fd_sc_hd__fill_2
X_4569_ clknet_leaf_6_clk _0290_ tree_instances\[0\].u_tree.rst_n VGND VGND VPWR VPWR
+ tree_instances\[7\].u_tree.frame_id_out\[2\] sky130_fd_sc_hd__dfrtp_1
XTAP_TAPCELL_ROW_68_893 VGND VPWR sky130_fd_sc_hd__tapvpwrvgnd_1
XFILLER_0_86_209 VPWR VGND VPWR VGND sky130_ef_sc_hd__decap_12
XFILLER_0_79_272 VGND VGND VPWR VPWR sky130_fd_sc_hd__fill_1
XTAP_TAPCELL_ROW_80_1004 VGND VPWR sky130_fd_sc_hd__tapvpwrvgnd_1
XANTENNA__4658__RESET_B net12 VGND VGND VPWR VPWR sky130_fd_sc_hd__diode_2
XFILLER_0_39_136 VGND VGND VPWR VPWR sky130_fd_sc_hd__decap_8
XFILLER_0_67_489 VGND VGND VPWR VPWR sky130_fd_sc_hd__fill_2
XTAP_TAPCELL_ROW_23_440 VGND VPWR sky130_fd_sc_hd__tapvpwrvgnd_1
XFILLER_0_82_448 VPWR VGND VPWR VGND sky130_ef_sc_hd__decap_12
XFILLER_0_54_139 VGND VGND VPWR VPWR sky130_fd_sc_hd__fill_1
XFILLER_0_2_409 VGND VGND VPWR VPWR sky130_fd_sc_hd__fill_2
XFILLER_0_35_386 VGND VGND VPWR VPWR sky130_fd_sc_hd__fill_2
XFILLER_0_50_334 VGND VGND VPWR VPWR sky130_fd_sc_hd__fill_2
XFILLER_0_23_559 VGND VGND VPWR VPWR sky130_fd_sc_hd__fill_1
XFILLER_0_49_28 VGND VGND VPWR VPWR sky130_fd_sc_hd__fill_2
XTAP_TAPCELL_ROW_91_1122 VGND VPWR sky130_fd_sc_hd__tapvpwrvgnd_1
XFILLER_0_10_209 VPWR VGND VPWR VGND sky130_ef_sc_hd__decap_12
XFILLER_0_49_39 VGND VGND VPWR VPWR sky130_fd_sc_hd__decap_3
XTAP_TAPCELL_ROW_89_1095 VGND VPWR sky130_fd_sc_hd__tapvpwrvgnd_1
XFILLER_0_85_220 VGND VGND VPWR VPWR sky130_fd_sc_hd__decap_4
X_3940_ tree_instances\[5\].u_tree.pipeline_valid\[0\] tree_instances\[5\].u_tree.tree_state\[0\]
+ VGND VGND VPWR VPWR _1330_ sky130_fd_sc_hd__nand2_1
XANTENNA__4399__RESET_B net13 VGND VGND VPWR VPWR sky130_fd_sc_hd__diode_2
X_3871_ _1280_ VGND VGND VPWR VPWR _1281_ sky130_fd_sc_hd__clkbuf_1
XFILLER_0_18_309 VPWR VGND VPWR VGND sky130_ef_sc_hd__decap_12
XANTENNA_clkbuf_leaf_50_clk_A clknet_3_5__leaf_clk VGND VGND VPWR VPWR sky130_fd_sc_hd__diode_2
X_2822_ _2125_ VGND VGND VPWR VPWR _0094_ sky130_fd_sc_hd__clkbuf_1
XFILLER_0_5_225 VPWR VGND VPWR VGND sky130_ef_sc_hd__decap_12
X_2753_ _2048_ VGND VGND VPWR VPWR _2064_ sky130_fd_sc_hd__clkbuf_1
XANTENNA_clkbuf_leaf_65_clk_A clknet_3_1__leaf_clk VGND VGND VPWR VPWR sky130_fd_sc_hd__diode_2
XANTENNA__3318__A1 _0675_ VGND VGND VPWR VPWR sky130_fd_sc_hd__diode_2
X_2684_ _1932_ tree_instances\[1\].u_tree.prediction_valid VGND VGND VPWR VPWR _0096_
+ sky130_fd_sc_hd__nor2_1
XFILLER_0_41_345 VGND VGND VPWR VPWR sky130_fd_sc_hd__fill_2
XFILLER_0_41_367 VGND VGND VPWR VPWR sky130_fd_sc_hd__fill_2
X_4423_ clknet_leaf_55_clk _0169_ tree_instances\[0\].u_tree.rst_n VGND VGND VPWR
+ VPWR tree_instances\[2\].u_tree.pipeline_current_node\[0\]\[1\] sky130_fd_sc_hd__dfrtp_1
XFILLER_0_41_378 VPWR VGND VPWR VGND sky130_ef_sc_hd__decap_12
X_4354_ clknet_leaf_28_clk _0114_ net13 VGND VGND VPWR VPWR tree_instances\[0\].u_tree.frame_id_in\[3\]
+ sky130_fd_sc_hd__dfrtp_1
X_3305_ _0941_ VGND VGND VPWR VPWR _0151_ sky130_fd_sc_hd__clkbuf_1
XFILLER_0_1_497 VGND VGND VPWR VPWR sky130_fd_sc_hd__decap_6
X_4285_ _1525_ VGND VGND VPWR VPWR _0547_ sky130_fd_sc_hd__clkbuf_1
X_3236_ _0885_ _0896_ complete_votes\[4\] _0645_ VGND VGND VPWR VPWR _0904_ sky130_fd_sc_hd__o211ai_1
X_3167_ _0653_ tree_instances\[11\].u_tree.frame_id_out\[2\] VGND VGND VPWR VPWR _0839_
+ sky130_fd_sc_hd__and2_1
XFILLER_0_96_529 VGND VGND VPWR VPWR sky130_fd_sc_hd__decap_3
X_3098_ _0733_ _0768_ tree_instances\[1\].u_tree.frame_id_out\[3\] _0690_ _0769_ VGND
+ VGND VPWR VPWR _0770_ sky130_fd_sc_hd__o221a_1
XANTENNA__2483__A _1574_ VGND VGND VPWR VPWR sky130_fd_sc_hd__diode_2
XTAP_TAPCELL_ROW_65_863 VGND VPWR sky130_fd_sc_hd__tapvpwrvgnd_1
XTAP_TAPCELL_ROW_37_576 VGND VPWR sky130_fd_sc_hd__tapvpwrvgnd_1
XANTENNA__4174__S _0018_ VGND VGND VPWR VPWR sky130_fd_sc_hd__diode_2
XFILLER_0_76_253 VGND VGND VPWR VPWR sky130_fd_sc_hd__fill_2
XANTENNA__4751__RESET_B net10 VGND VGND VPWR VPWR sky130_fd_sc_hd__diode_2
XANTENNA_clkbuf_leaf_18_clk_A clknet_3_2__leaf_clk VGND VGND VPWR VPWR sky130_fd_sc_hd__diode_2
XFILLER_0_9_553 VGND VGND VPWR VPWR sky130_fd_sc_hd__decap_6
XFILLER_0_91_223 VGND VGND VPWR VPWR sky130_fd_sc_hd__fill_1
XTAP_TAPCELL_ROW_20_410 VGND VPWR sky130_fd_sc_hd__tapvpwrvgnd_1
XFILLER_0_72_481 VGND VGND VPWR VPWR sky130_fd_sc_hd__decap_8
XFILLER_0_17_386 VGND VGND VPWR VPWR sky130_fd_sc_hd__decap_3
XFILLER_0_4_291 VGND VGND VPWR VPWR sky130_fd_sc_hd__decap_6
XFILLER_0_32_389 VPWR VGND VPWR VGND sky130_ef_sc_hd__decap_12
XANTENNA__4839__RESET_B net10 VGND VGND VPWR VPWR sky130_fd_sc_hd__diode_2
XANTENNA__4492__RESET_B net11 VGND VGND VPWR VPWR sky130_fd_sc_hd__diode_2
XFILLER_0_82_201 VPWR VGND VPWR VGND sky130_ef_sc_hd__decap_12
XANTENNA__4421__RESET_B net10 VGND VGND VPWR VPWR sky130_fd_sc_hd__diode_2
XFILLER_0_63_481 VGND VGND VPWR VPWR sky130_fd_sc_hd__decap_3
Xclkload16 clknet_leaf_62_clk VGND VGND VPWR VPWR clkload16/Y sky130_fd_sc_hd__clkinv_2
Xclkload27 clknet_leaf_16_clk VGND VGND VPWR VPWR clkload27/Y sky130_fd_sc_hd__clkinv_4
Xclkload49 clknet_leaf_53_clk VGND VGND VPWR VPWR clkload49/Y sky130_fd_sc_hd__clkinv_4
Xclkload38 clknet_leaf_54_clk VGND VGND VPWR VPWR clkload38/Y sky130_fd_sc_hd__clkinv_2
XFILLER_0_11_529 VPWR VGND VPWR VGND sky130_ef_sc_hd__decap_12
XFILLER_0_2_239 VGND VGND VPWR VPWR sky130_fd_sc_hd__decap_6
XFILLER_0_23_378 VGND VGND VPWR VPWR sky130_fd_sc_hd__decap_3
XFILLER_0_50_153 VGND VGND VPWR VPWR sky130_fd_sc_hd__decap_6
XPHY_EDGE_ROW_10_Left_107 VGND VGND VPWR VPWR sky130_fd_sc_hd__decap_3
XFILLER_0_50_197 VGND VGND VPWR VPWR sky130_fd_sc_hd__decap_6
XTAP_TAPCELL_ROW_8_290 VGND VPWR sky130_fd_sc_hd__tapvpwrvgnd_1
X_4070_ _1891_ _1396_ _0028_ tree_instances\[2\].u_tree.pipeline_valid\[0\] VGND VGND
+ VPWR VPWR _0461_ sky130_fd_sc_hd__o2bb2a_1
XTAP_TAPCELL_ROW_79_999 VGND VPWR sky130_fd_sc_hd__tapvpwrvgnd_1
X_3021_ _0686_ tree_instances\[6\].u_tree.frame_id_out\[1\] tree_instances\[6\].u_tree.frame_id_out\[3\]
+ _0691_ _0692_ VGND VGND VPWR VPWR _0693_ sky130_fd_sc_hd__a221o_1
XFILLER_0_78_507 VPWR VGND VPWR VGND sky130_ef_sc_hd__decap_12
XANTENNA__4509__RESET_B net13 VGND VGND VPWR VPWR sky130_fd_sc_hd__diode_2
XTAP_TAPCELL_ROW_62_833 VGND VPWR sky130_fd_sc_hd__tapvpwrvgnd_1
XFILLER_0_86_573 VGND VGND VPWR VPWR sky130_fd_sc_hd__fill_1
X_3923_ _1579_ _1050_ _0606_ tree_instances\[12\].u_tree.ready_for_next VGND VGND
+ VPWR VPWR _0397_ sky130_fd_sc_hd__a22o_1
XFILLER_0_58_253 VPWR VGND VPWR VGND sky130_ef_sc_hd__decap_12
XTAP_TAPCELL_ROW_34_546 VGND VPWR sky130_fd_sc_hd__tapvpwrvgnd_1
XFILLER_0_6_501 VPWR VGND VPWR VGND sky130_ef_sc_hd__decap_12
XFILLER_0_18_139 VGND VGND VPWR VPWR sky130_fd_sc_hd__fill_1
XFILLER_0_46_459 VGND VGND VPWR VPWR sky130_fd_sc_hd__decap_4
X_3854_ tree_instances\[11\].u_tree.frame_id_out\[0\] tree_instances\[11\].u_tree.pipeline_frame_id\[0\]\[0\]
+ _1595_ VGND VGND VPWR VPWR _1271_ sky130_fd_sc_hd__mux2_1
XFILLER_0_6_545 VPWR VGND VPWR VGND sky130_ef_sc_hd__decap_12
X_2805_ _2108_ VGND VGND VPWR VPWR _2109_ sky130_fd_sc_hd__clkbuf_1
XANTENNA__3539__A1 _0682_ VGND VGND VPWR VPWR sky130_fd_sc_hd__diode_2
XFILLER_0_33_109 VGND VGND VPWR VPWR sky130_fd_sc_hd__decap_3
X_3785_ _1235_ VGND VGND VPWR VPWR _0337_ sky130_fd_sc_hd__clkbuf_1
X_2736_ _1775_ VGND VGND VPWR VPWR _2047_ sky130_fd_sc_hd__clkbuf_1
X_2667_ _1985_ VGND VGND VPWR VPWR _1989_ sky130_fd_sc_hd__clkbuf_1
X_4406_ clknet_leaf_31_clk _0153_ net13 VGND VGND VPWR VPWR tree_instances\[1\].u_tree.pipeline_current_node\[0\]\[6\]
+ sky130_fd_sc_hd__dfrtp_1
XFILLER_0_67_3 VGND VGND VPWR VPWR sky130_fd_sc_hd__decap_8
X_2598_ _1929_ VGND VGND VPWR VPWR _1930_ sky130_fd_sc_hd__clkbuf_1
XANTENNA__3711__A1 _1192_ VGND VGND VPWR VPWR sky130_fd_sc_hd__diode_2
XFILLER_0_1_272 VGND VGND VPWR VPWR sky130_fd_sc_hd__decap_3
XFILLER_0_10_573 VGND VGND VPWR VPWR sky130_fd_sc_hd__fill_1
X_4337_ clknet_leaf_49_clk _0060_ net10 VGND VGND VPWR VPWR tree_instances\[18\].u_tree.tree_state\[0\]
+ sky130_fd_sc_hd__dfstp_1
X_4268_ _1516_ VGND VGND VPWR VPWR _0539_ sky130_fd_sc_hd__clkbuf_1
X_3219_ _0889_ _0885_ VGND VGND VPWR VPWR _0890_ sky130_fd_sc_hd__or2_1
X_4199_ _1433_ _1478_ VGND VGND VPWR VPWR _1481_ sky130_fd_sc_hd__and2_1
XFILLER_0_96_337 VPWR VGND VPWR VGND sky130_ef_sc_hd__decap_12
XFILLER_0_77_551 VGND VGND VPWR VPWR sky130_fd_sc_hd__decap_8
XFILLER_0_77_540 VGND VGND VPWR VPWR sky130_fd_sc_hd__decap_3
XFILLER_0_77_573 VGND VGND VPWR VPWR sky130_fd_sc_hd__fill_1
XFILLER_0_64_245 VGND VGND VPWR VPWR sky130_fd_sc_hd__decap_6
XFILLER_0_9_383 VGND VGND VPWR VPWR sky130_fd_sc_hd__decap_8
XFILLER_0_60_484 VPWR VGND VPWR VGND sky130_ef_sc_hd__decap_12
XFILLER_0_32_153 VGND VGND VPWR VPWR sky130_fd_sc_hd__fill_1
XFILLER_0_32_175 VGND VGND VPWR VPWR sky130_fd_sc_hd__fill_1
XFILLER_0_32_197 VGND VGND VPWR VPWR sky130_fd_sc_hd__fill_2
XFILLER_0_46_29 VPWR VGND VPWR VGND sky130_ef_sc_hd__decap_12
XTAP_TAPCELL_ROW_5_260 VGND VPWR sky130_fd_sc_hd__tapvpwrvgnd_1
XANTENNA__4673__RESET_B net11 VGND VGND VPWR VPWR sky130_fd_sc_hd__diode_2
XTAP_TAPCELL_ROW_76_969 VGND VPWR sky130_fd_sc_hd__tapvpwrvgnd_1
XFILLER_0_87_337 VGND VGND VPWR VPWR sky130_fd_sc_hd__fill_2
XANTENNA__4602__RESET_B net9 VGND VGND VPWR VPWR sky130_fd_sc_hd__diode_2
XTAP_TAPCELL_ROW_86_1065 VGND VPWR sky130_fd_sc_hd__tapvpwrvgnd_1
XTAP_TAPCELL_ROW_31_516 VGND VPWR sky130_fd_sc_hd__tapvpwrvgnd_1
XFILLER_0_36_481 VGND VGND VPWR VPWR sky130_fd_sc_hd__fill_2
XFILLER_0_55_278 VGND VGND VPWR VPWR sky130_fd_sc_hd__fill_2
XFILLER_0_55_289 VGND VGND VPWR VPWR sky130_fd_sc_hd__decap_3
X_3570_ _1102_ VGND VGND VPWR VPWR _1103_ sky130_fd_sc_hd__clkbuf_1
XFILLER_0_87_25 VGND VGND VPWR VPWR sky130_fd_sc_hd__fill_1
X_2521_ _1864_ _1865_ VGND VGND VPWR VPWR _1866_ sky130_fd_sc_hd__nor2_1
XFILLER_0_11_98 VGND VGND VPWR VPWR sky130_fd_sc_hd__fill_2
XFILLER_0_3_559 VGND VGND VPWR VPWR sky130_fd_sc_hd__fill_1
XFILLER_0_11_337 VGND VGND VPWR VPWR sky130_fd_sc_hd__decap_8
X_2452_ _1794_ _1798_ _1803_ _1804_ VGND VGND VPWR VPWR _1805_ sky130_fd_sc_hd__and4_1
X_2383_ _1740_ _1743_ VGND VGND VPWR VPWR _1744_ sky130_fd_sc_hd__or2_1
XPHY_EDGE_ROW_18_Right_18 VGND VGND VPWR VPWR sky130_fd_sc_hd__decap_3
X_4122_ tree_instances\[18\].u_tree.pipeline_current_node\[0\]\[1\] VGND VGND VPWR
+ VPWR _1428_ sky130_fd_sc_hd__clkbuf_1
X_4053_ _1388_ VGND VGND VPWR VPWR _0452_ sky130_fd_sc_hd__clkbuf_1
X_3004_ tree_instances\[0\].u_tree.frame_id_in\[3\] VGND VGND VPWR VPWR _0678_ sky130_fd_sc_hd__buf_2
XANTENNA__4343__RESET_B tree_instances\[0\].u_tree.rst_n VGND VGND VPWR VPWR sky130_fd_sc_hd__diode_2
XFILLER_0_78_359 VGND VGND VPWR VPWR sky130_fd_sc_hd__fill_2
XTAP_TAPCELL_ROW_47_682 VGND VPWR sky130_fd_sc_hd__tapvpwrvgnd_1
XFILLER_0_59_573 VGND VGND VPWR VPWR sky130_fd_sc_hd__fill_1
XTAP_TAPCELL_ROW_19_395 VGND VPWR sky130_fd_sc_hd__tapvpwrvgnd_1
XPHY_EDGE_ROW_27_Right_27 VGND VGND VPWR VPWR sky130_fd_sc_hd__decap_3
X_3906_ _1305_ VGND VGND VPWR VPWR _0388_ sky130_fd_sc_hd__clkbuf_1
XFILLER_0_52_94 VGND VGND VPWR VPWR sky130_fd_sc_hd__decap_8
X_4886_ clknet_leaf_27_clk _0558_ net11 VGND VGND VPWR VPWR tree_instances\[20\].u_tree.pipeline_frame_id\[0\]\[2\]
+ sky130_fd_sc_hd__dfrtp_1
X_3837_ _1262_ VGND VGND VPWR VPWR _0362_ sky130_fd_sc_hd__clkbuf_1
XFILLER_0_6_386 VGND VGND VPWR VPWR sky130_fd_sc_hd__decap_4
X_3768_ tree_instances\[9\].u_tree.frame_id_out\[2\] tree_instances\[9\].u_tree.pipeline_frame_id\[0\]\[2\]
+ _1649_ VGND VGND VPWR VPWR _1226_ sky130_fd_sc_hd__mux2_1
X_2719_ _2030_ VGND VGND VPWR VPWR _2035_ sky130_fd_sc_hd__clkbuf_1
X_3699_ _1186_ VGND VGND VPWR VPWR _0300_ sky130_fd_sc_hd__clkbuf_1
XFILLER_0_14_197 VGND VGND VPWR VPWR sky130_fd_sc_hd__fill_2
XPHY_EDGE_ROW_36_Right_36 VGND VGND VPWR VPWR sky130_fd_sc_hd__decap_3
XTAP_TAPCELL_ROW_2_230 VGND VPWR sky130_fd_sc_hd__tapvpwrvgnd_1
XTAP_TAPCELL_ROW_73_939 VGND VPWR sky130_fd_sc_hd__tapvpwrvgnd_1
XPHY_EDGE_ROW_45_Right_45 VGND VGND VPWR VPWR sky130_fd_sc_hd__decap_3
XFILLER_0_65_532 VGND VGND VPWR VPWR sky130_fd_sc_hd__fill_1
XFILLER_0_65_510 VGND VGND VPWR VPWR sky130_fd_sc_hd__fill_2
XFILLER_0_80_502 VGND VGND VPWR VPWR sky130_fd_sc_hd__fill_1
XFILLER_0_65_554 VGND VGND VPWR VPWR sky130_fd_sc_hd__decap_3
XFILLER_0_9_180 VPWR VGND VPWR VGND sky130_ef_sc_hd__decap_12
XFILLER_0_37_278 VGND VGND VPWR VPWR sky130_fd_sc_hd__fill_2
XANTENNA__4176__A1 _0678_ VGND VGND VPWR VPWR sky130_fd_sc_hd__diode_2
XFILLER_0_0_529 VGND VGND VPWR VPWR sky130_fd_sc_hd__decap_3
XPHY_EDGE_ROW_54_Right_54 VGND VGND VPWR VPWR sky130_fd_sc_hd__decap_3
XANTENNA__4854__RESET_B net13 VGND VGND VPWR VPWR sky130_fd_sc_hd__diode_2
XANTENNA__4100__A1 tree_instances\[0\].u_tree.frame_id_in\[4\] VGND VGND VPWR VPWR
+ sky130_fd_sc_hd__diode_2
XPHY_EDGE_ROW_63_Right_63 VGND VGND VPWR VPWR sky130_fd_sc_hd__decap_3
XFILLER_0_87_167 VGND VGND VPWR VPWR sky130_fd_sc_hd__fill_1
XTAP_TAPCELL_ROW_16_365 VGND VPWR sky130_fd_sc_hd__tapvpwrvgnd_1
XFILLER_0_28_212 VGND VGND VPWR VPWR sky130_fd_sc_hd__fill_1
XTAP_TAPCELL_ROW_44_652 VGND VPWR sky130_fd_sc_hd__tapvpwrvgnd_1
X_4740_ clknet_leaf_39_clk _0438_ net10 VGND VGND VPWR VPWR tree_instances\[14\].u_tree.frame_id_out\[4\]
+ sky130_fd_sc_hd__dfrtp_1
XFILLER_0_7_139 VPWR VGND VPWR VGND sky130_ef_sc_hd__decap_12
XFILLER_0_28_256 VGND VGND VPWR VPWR sky130_fd_sc_hd__fill_2
X_4671_ clknet_leaf_11_clk _0376_ net12 VGND VGND VPWR VPWR tree_instances\[11\].u_tree.ready_for_next
+ sky130_fd_sc_hd__dfstp_1
XFILLER_0_71_546 VGND VGND VPWR VPWR sky130_fd_sc_hd__fill_1
X_3622_ tree_instances\[7\].u_tree.pipeline_current_node\[0\]\[0\] VGND VGND VPWR
+ VPWR _1136_ sky130_fd_sc_hd__clkbuf_1
XFILLER_0_3_301 VGND VGND VPWR VPWR sky130_fd_sc_hd__fill_2
XPHY_EDGE_ROW_72_Right_72 VGND VGND VPWR VPWR sky130_fd_sc_hd__decap_3
X_3553_ tree_instances\[10\].u_tree.tree_state\[0\] _1596_ VGND VGND VPWR VPWR _1090_
+ sky130_fd_sc_hd__nand2_1
XFILLER_0_51_281 VGND VGND VPWR VPWR sky130_fd_sc_hd__decap_8
XFILLER_0_11_156 VPWR VGND VPWR VGND sky130_ef_sc_hd__decap_12
X_2504_ _1849_ VGND VGND VPWR VPWR _1850_ sky130_fd_sc_hd__clkbuf_1
XFILLER_0_3_389 VGND VGND VPWR VPWR sky130_fd_sc_hd__decap_3
X_3484_ tree_instances\[4\].u_tree.frame_id_out\[2\] tree_instances\[4\].u_tree.pipeline_frame_id\[0\]\[2\]
+ _1834_ VGND VGND VPWR VPWR _1046_ sky130_fd_sc_hd__mux2_1
X_2435_ tree_instances\[16\].u_tree.pipeline_current_node\[0\]\[6\] VGND VGND VPWR
+ VPWR _1789_ sky130_fd_sc_hd__clkbuf_1
XANTENNA__4524__RESET_B net11 VGND VGND VPWR VPWR sky130_fd_sc_hd__diode_2
X_2366_ _1714_ _1715_ _1726_ _1728_ tree_instances\[13\].u_tree.tree_state\[2\] VGND
+ VGND VPWR VPWR _0009_ sky130_fd_sc_hd__o41a_1
XFILLER_0_47_50 VGND VGND VPWR VPWR sky130_fd_sc_hd__fill_2
X_4105_ _1415_ VGND VGND VPWR VPWR _0477_ sky130_fd_sc_hd__clkbuf_1
XPHY_EDGE_ROW_81_Right_81 VGND VGND VPWR VPWR sky130_fd_sc_hd__decap_3
X_2297_ _1666_ tree_instances\[8\].u_tree.pipeline_valid\[0\] VGND VGND VPWR VPWR
+ _1667_ sky130_fd_sc_hd__or2_1
XFILLER_0_2_41 VPWR VGND VPWR VGND sky130_ef_sc_hd__decap_12
X_4036_ _1329_ _1376_ VGND VGND VPWR VPWR _1380_ sky130_fd_sc_hd__and2_1
XFILLER_0_78_178 VGND VGND VPWR VPWR sky130_fd_sc_hd__decap_3
XFILLER_0_78_156 VPWR VGND VPWR VGND sky130_ef_sc_hd__decap_12
XTAP_TAPCELL_ROW_70_909 VGND VPWR sky130_fd_sc_hd__tapvpwrvgnd_1
XFILLER_0_66_307 VGND VGND VPWR VPWR sky130_fd_sc_hd__fill_1
XFILLER_0_19_223 VGND VGND VPWR VPWR sky130_fd_sc_hd__fill_1
XFILLER_0_19_245 VGND VGND VPWR VPWR sky130_fd_sc_hd__fill_2
XANTENNA__4182__S _1827_ VGND VGND VPWR VPWR sky130_fd_sc_hd__diode_2
XFILLER_0_47_554 VGND VGND VPWR VPWR sky130_fd_sc_hd__fill_1
X_4869_ clknet_leaf_36_clk _0062_ net10 VGND VGND VPWR VPWR tree_instances\[19\].u_tree.tree_state\[3\]
+ sky130_fd_sc_hd__dfrtp_1
XPHY_EDGE_ROW_90_Right_90 VGND VGND VPWR VPWR sky130_fd_sc_hd__decap_3
XFILLER_0_74_395 VGND VGND VPWR VPWR sky130_fd_sc_hd__fill_2
XANTENNA__3905__A1 _1124_ VGND VGND VPWR VPWR sky130_fd_sc_hd__diode_2
XFILLER_0_30_421 VGND VGND VPWR VPWR sky130_fd_sc_hd__decap_6
XFILLER_0_42_292 VGND VGND VPWR VPWR sky130_fd_sc_hd__decap_8
XFILLER_0_30_465 VGND VGND VPWR VPWR sky130_fd_sc_hd__decap_8
XTAP_TAPCELL_ROW_58_788 VGND VPWR sky130_fd_sc_hd__tapvpwrvgnd_1
XTAP_TAPCELL_ROW_83_1035 VGND VPWR sky130_fd_sc_hd__tapvpwrvgnd_1
XFILLER_0_69_167 VGND VGND VPWR VPWR sky130_fd_sc_hd__fill_1
XFILLER_0_69_189 VGND VGND VPWR VPWR sky130_fd_sc_hd__fill_2
XFILLER_0_57_329 VGND VGND VPWR VPWR sky130_fd_sc_hd__decap_4
XFILLER_0_38_543 VGND VGND VPWR VPWR sky130_fd_sc_hd__fill_1
XTAP_TAPCELL_ROW_41_622 VGND VPWR sky130_fd_sc_hd__tapvpwrvgnd_1
XTAP_TAPCELL_ROW_13_335 VGND VPWR sky130_fd_sc_hd__tapvpwrvgnd_1
XFILLER_0_80_365 VGND VGND VPWR VPWR sky130_fd_sc_hd__decap_4
XFILLER_0_21_410 VPWR VGND VPWR VGND sky130_ef_sc_hd__decap_12
XTAP_TAPCELL_ROW_94_1153 VGND VPWR sky130_fd_sc_hd__tapvpwrvgnd_1
XFILLER_0_0_337 VPWR VGND VPWR VGND sky130_ef_sc_hd__decap_12
X_2220_ tree_instances\[10\].u_tree.tree_state\[0\] _1596_ _1597_ VGND VGND VPWR VPWR
+ _0045_ sky130_fd_sc_hd__a21o_1
XFILLER_0_84_15 VPWR VGND VPWR VGND sky130_ef_sc_hd__decap_12
XTAP_TAPCELL_ROW_49_700 VGND VPWR sky130_fd_sc_hd__tapvpwrvgnd_1
XFILLER_0_17_31 VGND VGND VPWR VPWR sky130_fd_sc_hd__fill_2
XANTENNA__3177__B_N tree_instances\[20\].u_tree.frame_id_out\[4\] VGND VGND VPWR VPWR
+ sky130_fd_sc_hd__diode_2
XFILLER_0_48_307 VGND VGND VPWR VPWR sky130_fd_sc_hd__fill_1
XFILLER_0_48_318 VPWR VGND VPWR VGND sky130_ef_sc_hd__decap_12
XFILLER_0_75_137 VGND VGND VPWR VPWR sky130_fd_sc_hd__decap_8
XFILLER_0_29_521 VPWR VGND VPWR VGND sky130_ef_sc_hd__decap_12
XFILLER_0_33_63 VGND VGND VPWR VPWR sky130_fd_sc_hd__fill_1
XFILLER_0_33_74 VGND VGND VPWR VPWR sky130_fd_sc_hd__fill_1
X_2984_ _0661_ VGND VGND VPWR VPWR _0662_ sky130_fd_sc_hd__clkbuf_4
X_4723_ clknet_leaf_37_clk _0421_ net10 VGND VGND VPWR VPWR tree_instances\[14\].u_tree.pipeline_current_node\[0\]\[1\]
+ sky130_fd_sc_hd__dfrtp_1
XANTENNA__3200__A _0654_ VGND VGND VPWR VPWR sky130_fd_sc_hd__diode_2
XANTENNA__3060__A1 _0651_ VGND VGND VPWR VPWR sky130_fd_sc_hd__diode_2
XFILLER_0_56_351 VGND VGND VPWR VPWR sky130_fd_sc_hd__fill_2
XANTENNA__3060__B2 _0702_ VGND VGND VPWR VPWR sky130_fd_sc_hd__diode_2
X_4654_ clknet_leaf_13_clk _0359_ tree_instances\[0\].u_tree.rst_n VGND VGND VPWR
+ VPWR tree_instances\[11\].u_tree.pipeline_current_node\[0\]\[2\] sky130_fd_sc_hd__dfrtp_1
X_3605_ _1127_ VGND VGND VPWR VPWR _0265_ sky130_fd_sc_hd__clkbuf_1
X_4585_ clknet_leaf_23_clk _0305_ net11 VGND VGND VPWR VPWR tree_instances\[8\].u_tree.pipeline_frame_id\[0\]\[2\]
+ sky130_fd_sc_hd__dfrtp_1
XFILLER_0_12_421 VGND VGND VPWR VPWR sky130_fd_sc_hd__fill_2
XANTENNA__4776__RESET_B net13 VGND VGND VPWR VPWR sky130_fd_sc_hd__diode_2
X_3536_ _1081_ VGND VGND VPWR VPWR _0242_ sky130_fd_sc_hd__clkbuf_1
XFILLER_0_12_498 VPWR VGND VPWR VGND sky130_ef_sc_hd__decap_12
XANTENNA__4705__RESET_B net9 VGND VGND VPWR VPWR sky130_fd_sc_hd__diode_2
XFILLER_0_58_82 VGND VGND VPWR VPWR sky130_fd_sc_hd__fill_2
X_3467_ _1037_ VGND VGND VPWR VPWR _0217_ sky130_fd_sc_hd__clkbuf_1
X_3398_ _2124_ _0996_ VGND VGND VPWR VPWR _0997_ sky130_fd_sc_hd__and2_1
X_2418_ _1770_ _1772_ VGND VGND VPWR VPWR _1773_ sky130_fd_sc_hd__or2_1
X_2349_ tree_instances\[6\].u_tree.tree_state\[2\] _1704_ _1712_ tree_instances\[6\].u_tree.tree_state\[1\]
+ VGND VGND VPWR VPWR _0076_ sky130_fd_sc_hd__a31o_1
XANTENNA__2486__A _1666_ VGND VGND VPWR VPWR sky130_fd_sc_hd__diode_2
X_4019_ tree_instances\[14\].u_tree.frame_id_out\[2\] tree_instances\[14\].u_tree.pipeline_frame_id\[0\]\[2\]
+ _1889_ VGND VGND VPWR VPWR _1371_ sky130_fd_sc_hd__mux2_1
XTAP_TAPCELL_ROW_55_758 VGND VPWR sky130_fd_sc_hd__tapvpwrvgnd_1
XFILLER_0_94_424 VGND VGND VPWR VPWR sky130_fd_sc_hd__decap_4
XFILLER_0_79_498 VGND VGND VPWR VPWR sky130_fd_sc_hd__fill_2
XFILLER_0_66_126 VGND VGND VPWR VPWR sky130_fd_sc_hd__fill_1
XPHY_EDGE_ROW_0_Right_0 VGND VGND VPWR VPWR sky130_fd_sc_hd__decap_3
XFILLER_0_94_468 VGND VGND VPWR VPWR sky130_fd_sc_hd__decap_8
XFILLER_0_74_192 VGND VGND VPWR VPWR sky130_fd_sc_hd__fill_2
XFILLER_0_74_170 VGND VGND VPWR VPWR sky130_fd_sc_hd__fill_2
XFILLER_0_62_321 VGND VGND VPWR VPWR sky130_fd_sc_hd__decap_6
XTAP_TAPCELL_ROW_10_305 VGND VPWR sky130_fd_sc_hd__tapvpwrvgnd_1
XFILLER_0_62_398 VGND VGND VPWR VPWR sky130_fd_sc_hd__fill_1
XFILLER_0_15_281 VGND VGND VPWR VPWR sky130_fd_sc_hd__decap_6
XFILLER_0_22_218 VPWR VGND VPWR VGND sky130_ef_sc_hd__decap_12
XFILLER_0_50_549 VGND VGND VPWR VPWR sky130_fd_sc_hd__fill_1
XANTENNA__4446__RESET_B net9 VGND VGND VPWR VPWR sky130_fd_sc_hd__diode_2
XFILLER_0_89_218 VGND VGND VPWR VPWR sky130_fd_sc_hd__fill_2
XFILLER_0_54_29 VPWR VGND VPWR VGND sky130_ef_sc_hd__decap_12
XFILLER_0_57_159 VGND VGND VPWR VPWR sky130_fd_sc_hd__decap_3
XTAP_TAPCELL_ROW_26_471 VGND VPWR sky130_fd_sc_hd__tapvpwrvgnd_1
XANTENNA__3020__A _0654_ VGND VGND VPWR VPWR sky130_fd_sc_hd__diode_2
XFILLER_0_38_373 VGND VGND VPWR VPWR sky130_fd_sc_hd__fill_1
XFILLER_0_53_332 VGND VGND VPWR VPWR sky130_fd_sc_hd__decap_4
XFILLER_0_41_505 VGND VGND VPWR VPWR sky130_fd_sc_hd__decap_8
XFILLER_0_41_516 VPWR VGND VPWR VGND sky130_ef_sc_hd__decap_12
XFILLER_0_80_195 VGND VGND VPWR VPWR sky130_fd_sc_hd__fill_1
XFILLER_0_79_37 VGND VGND VPWR VPWR sky130_fd_sc_hd__fill_2
X_4370_ clknet_leaf_9_clk _0079_ net12 VGND VGND VPWR VPWR tree_instances\[8\].u_tree.tree_state\[0\]
+ sky130_fd_sc_hd__dfstp_1
X_3321_ _0949_ VGND VGND VPWR VPWR _0159_ sky130_fd_sc_hd__clkbuf_1
XFILLER_0_21_273 VGND VGND VPWR VPWR sky130_fd_sc_hd__decap_6
XFILLER_0_95_69 VGND VGND VPWR VPWR sky130_fd_sc_hd__decap_4
X_3252_ _0913_ VGND VGND VPWR VPWR _0126_ sky130_fd_sc_hd__clkbuf_1
X_3183_ _0662_ _0853_ _0854_ VGND VGND VPWR VPWR _0855_ sky130_fd_sc_hd__a21oi_1
X_2203_ tree_instances\[9\].u_tree.pipeline_current_node\[0\]\[2\] VGND VGND VPWR
+ VPWR _1583_ sky130_fd_sc_hd__clkbuf_1
XFILLER_0_28_85 VGND VGND VPWR VPWR sky130_fd_sc_hd__decap_6
XFILLER_0_44_73 VGND VGND VPWR VPWR sky130_fd_sc_hd__decap_8
XFILLER_0_76_457 VGND VGND VPWR VPWR sky130_fd_sc_hd__fill_2
XTAP_TAPCELL_ROW_52_728 VGND VPWR sky130_fd_sc_hd__tapvpwrvgnd_1
XFILLER_0_91_416 VPWR VGND VPWR VGND sky130_ef_sc_hd__decap_12
XFILLER_0_8_256 VGND VGND VPWR VPWR sky130_fd_sc_hd__fill_2
X_2967_ _0648_ _1647_ VGND VGND VPWR VPWR _0649_ sky130_fd_sc_hd__nor2_2
X_4706_ clknet_leaf_2_clk _0409_ net9 VGND VGND VPWR VPWR tree_instances\[13\].u_tree.pipeline_frame_id\[0\]\[1\]
+ sky130_fd_sc_hd__dfrtp_1
X_2898_ tree_instances\[17\].u_tree.tree_state\[0\] VGND VGND VPWR VPWR _0603_ sky130_fd_sc_hd__inv_2
X_4637_ clknet_leaf_4_clk _0347_ tree_instances\[0\].u_tree.rst_n VGND VGND VPWR VPWR
+ tree_instances\[10\].u_tree.pipeline_frame_id\[0\]\[3\] sky130_fd_sc_hd__dfrtp_1
X_4568_ clknet_leaf_6_clk _0289_ tree_instances\[0\].u_tree.rst_n VGND VGND VPWR VPWR
+ tree_instances\[7\].u_tree.frame_id_out\[1\] sky130_fd_sc_hd__dfrtp_1
XFILLER_0_40_560 VPWR VGND VPWR VGND sky130_ef_sc_hd__decap_12
X_3519_ tree_instances\[5\].u_tree.pipeline_current_node\[0\]\[5\] VGND VGND VPWR
+ VPWR _1071_ sky130_fd_sc_hd__clkbuf_1
X_4499_ clknet_leaf_3_clk _0083_ tree_instances\[0\].u_tree.rst_n VGND VGND VPWR VPWR
+ tree_instances\[10\].u_tree.tree_state\[3\] sky130_fd_sc_hd__dfrtp_1
XFILLER_0_67_413 VGND VGND VPWR VPWR sky130_fd_sc_hd__decap_4
XFILLER_0_67_402 VGND VGND VPWR VPWR sky130_fd_sc_hd__fill_2
XTAP_TAPCELL_ROW_80_1005 VGND VPWR sky130_fd_sc_hd__tapvpwrvgnd_1
XFILLER_0_67_446 VGND VGND VPWR VPWR sky130_fd_sc_hd__fill_2
XFILLER_0_94_276 VGND VGND VPWR VPWR sky130_fd_sc_hd__fill_2
XANTENNA__4698__RESET_B net9 VGND VGND VPWR VPWR sky130_fd_sc_hd__diode_2
XTAP_TAPCELL_ROW_23_441 VGND VPWR sky130_fd_sc_hd__tapvpwrvgnd_1
Xclkbuf_leaf_20_clk clknet_3_3__leaf_clk VGND VGND VPWR VPWR clknet_leaf_20_clk sky130_fd_sc_hd__clkbuf_4
Xload_slew9 tree_instances\[0\].u_tree.rst_n VGND VGND VPWR VPWR net9 sky130_fd_sc_hd__clkbuf_16
XFILLER_0_23_505 VPWR VGND VPWR VGND sky130_ef_sc_hd__decap_12
XANTENNA__4627__RESET_B net9 VGND VGND VPWR VPWR sky130_fd_sc_hd__diode_2
XFILLER_0_50_346 VGND VGND VPWR VPWR sky130_fd_sc_hd__fill_2
XTAP_TAPCELL_ROW_91_1123 VGND VPWR sky130_fd_sc_hd__tapvpwrvgnd_1
XTAP_TAPCELL_ROW_89_1096 VGND VPWR sky130_fd_sc_hd__tapvpwrvgnd_1
X_3870_ _1279_ VGND VGND VPWR VPWR _1280_ sky130_fd_sc_hd__clkbuf_1
XFILLER_0_73_427 VGND VGND VPWR VPWR sky130_fd_sc_hd__fill_2
XANTENNA__3015__B2 _0686_ VGND VGND VPWR VPWR sky130_fd_sc_hd__diode_2
XANTENNA__3015__A1 _0648_ VGND VGND VPWR VPWR sky130_fd_sc_hd__diode_2
XFILLER_0_66_490 VGND VGND VPWR VPWR sky130_fd_sc_hd__fill_2
XFILLER_0_38_170 VGND VGND VPWR VPWR sky130_fd_sc_hd__decap_8
X_2821_ tree_instances\[18\].u_tree.prediction_valid _1670_ VGND VGND VPWR VPWR _2125_
+ sky130_fd_sc_hd__and2b_1
XFILLER_0_5_237 VGND VGND VPWR VPWR sky130_fd_sc_hd__decap_4
X_2752_ _2051_ VGND VGND VPWR VPWR _2063_ sky130_fd_sc_hd__clkbuf_1
XFILLER_0_26_365 VPWR VGND VPWR VGND sky130_ef_sc_hd__decap_12
Xclkbuf_leaf_11_clk clknet_3_2__leaf_clk VGND VGND VPWR VPWR clknet_leaf_11_clk sky130_fd_sc_hd__clkbuf_4
XANTENNA__4368__RESET_B net9 VGND VGND VPWR VPWR sky130_fd_sc_hd__diode_2
X_4422_ clknet_leaf_55_clk _0168_ tree_instances\[0\].u_tree.rst_n VGND VGND VPWR
+ VPWR tree_instances\[2\].u_tree.pipeline_current_node\[0\]\[0\] sky130_fd_sc_hd__dfrtp_1
X_2683_ _2000_ VGND VGND VPWR VPWR _2004_ sky130_fd_sc_hd__clkbuf_1
XFILLER_0_41_335 VGND VGND VPWR VPWR sky130_fd_sc_hd__fill_1
XFILLER_0_1_421 VPWR VGND VPWR VGND sky130_ef_sc_hd__decap_12
X_4353_ clknet_leaf_29_clk _0113_ net11 VGND VGND VPWR VPWR tree_instances\[0\].u_tree.frame_id_in\[2\]
+ sky130_fd_sc_hd__dfrtp_1
X_3304_ _0574_ _0936_ VGND VGND VPWR VPWR _0941_ sky130_fd_sc_hd__and2_1
X_4284_ _1441_ _1524_ VGND VGND VPWR VPWR _1525_ sky130_fd_sc_hd__and2_1
X_3235_ _1646_ _0901_ _0902_ _0903_ VGND VGND VPWR VPWR _0119_ sky130_fd_sc_hd__a31o_1
XFILLER_0_55_61 VPWR VGND VPWR VGND sky130_ef_sc_hd__decap_12
X_3166_ tree_instances\[11\].u_tree.frame_id_out\[3\] VGND VGND VPWR VPWR _0838_ sky130_fd_sc_hd__inv_2
X_3097_ _0653_ tree_instances\[1\].u_tree.frame_id_out\[2\] VGND VGND VPWR VPWR _0769_
+ sky130_fd_sc_hd__xnor2_1
XFILLER_0_12_3 VGND VGND VPWR VPWR sky130_fd_sc_hd__fill_2
XTAP_TAPCELL_ROW_37_577 VGND VPWR sky130_fd_sc_hd__tapvpwrvgnd_1
XFILLER_0_76_265 VGND VGND VPWR VPWR sky130_fd_sc_hd__decap_3
X_3999_ _1736_ _1354_ VGND VGND VPWR VPWR _1361_ sky130_fd_sc_hd__and2_1
XANTENNA__4791__RESET_B net13 VGND VGND VPWR VPWR sky130_fd_sc_hd__diode_2
XFILLER_0_17_310 VPWR VGND VPWR VGND sky130_ef_sc_hd__decap_12
XFILLER_0_29_181 VPWR VGND VPWR VGND sky130_ef_sc_hd__decap_12
XFILLER_0_91_279 VGND VGND VPWR VPWR sky130_fd_sc_hd__fill_1
XTAP_TAPCELL_ROW_20_411 VGND VPWR sky130_fd_sc_hd__tapvpwrvgnd_1
XANTENNA__4720__RESET_B net13 VGND VGND VPWR VPWR sky130_fd_sc_hd__diode_2
Xclkbuf_leaf_69_clk clknet_3_0__leaf_clk VGND VGND VPWR VPWR clknet_leaf_69_clk sky130_fd_sc_hd__clkbuf_4
XFILLER_0_95_541 VPWR VGND VPWR VGND sky130_ef_sc_hd__decap_12
XANTENNA__4879__RESET_B net10 VGND VGND VPWR VPWR sky130_fd_sc_hd__diode_2
XANTENNA__4808__RESET_B net12 VGND VGND VPWR VPWR sky130_fd_sc_hd__diode_2
XFILLER_0_82_224 VGND VGND VPWR VPWR sky130_fd_sc_hd__fill_2
XFILLER_0_82_213 VGND VGND VPWR VPWR sky130_fd_sc_hd__fill_2
XFILLER_0_55_449 VGND VGND VPWR VPWR sky130_fd_sc_hd__fill_2
XFILLER_0_82_246 VGND VGND VPWR VPWR sky130_fd_sc_hd__decap_6
Xclkload17 clknet_leaf_64_clk VGND VGND VPWR VPWR clkload17/Y sky130_fd_sc_hd__clkinv_8
XANTENNA__4461__RESET_B net9 VGND VGND VPWR VPWR sky130_fd_sc_hd__diode_2
XFILLER_0_35_162 VGND VGND VPWR VPWR sky130_fd_sc_hd__fill_2
Xclkload28 clknet_leaf_17_clk VGND VGND VPWR VPWR clkload28/X sky130_fd_sc_hd__clkbuf_1
Xclkload39 clknet_leaf_55_clk VGND VGND VPWR VPWR clkload39/Y sky130_fd_sc_hd__clkinv_1
XFILLER_0_50_121 VPWR VGND VPWR VGND sky130_ef_sc_hd__decap_12
XFILLER_0_76_27 VGND VGND VPWR VPWR sky130_fd_sc_hd__fill_1
XTAP_TAPCELL_ROW_8_291 VGND VPWR sky130_fd_sc_hd__tapvpwrvgnd_1
X_3020_ _0654_ tree_instances\[6\].u_tree.frame_id_out\[2\] VGND VGND VPWR VPWR _0692_
+ sky130_fd_sc_hd__xor2_1
Xclkbuf_leaf_0_clk clknet_3_0__leaf_clk VGND VGND VPWR VPWR clknet_leaf_0_clk sky130_fd_sc_hd__clkbuf_4
XFILLER_0_78_519 VPWR VGND VPWR VGND sky130_ef_sc_hd__decap_12
XFILLER_0_86_530 VGND VGND VPWR VPWR sky130_fd_sc_hd__fill_2
XFILLER_0_58_210 VPWR VGND VPWR VGND sky130_ef_sc_hd__decap_12
XFILLER_0_25_64 VPWR VGND VPWR VGND sky130_ef_sc_hd__decap_12
X_3922_ _1313_ VGND VGND VPWR VPWR _0396_ sky130_fd_sc_hd__clkbuf_1
XFILLER_0_58_265 VPWR VGND VPWR VGND sky130_ef_sc_hd__decap_12
XTAP_TAPCELL_ROW_34_547 VGND VPWR sky130_fd_sc_hd__tapvpwrvgnd_1
X_3853_ _1270_ VGND VGND VPWR VPWR _0370_ sky130_fd_sc_hd__clkbuf_1
XFILLER_0_73_268 VGND VGND VPWR VPWR sky130_fd_sc_hd__fill_2
XFILLER_0_6_513 VPWR VGND VPWR VGND sky130_ef_sc_hd__decap_12
X_2804_ _2107_ VGND VGND VPWR VPWR _2108_ sky130_fd_sc_hd__clkbuf_1
XFILLER_0_6_557 VPWR VGND VPWR VGND sky130_ef_sc_hd__decap_12
X_3784_ _0598_ _1232_ VGND VGND VPWR VPWR _1235_ sky130_fd_sc_hd__and2_1
XFILLER_0_14_346 VGND VGND VPWR VPWR sky130_fd_sc_hd__fill_2
XFILLER_0_41_110 VGND VGND VPWR VPWR sky130_fd_sc_hd__fill_2
X_2735_ _2046_ VGND VGND VPWR VPWR _0086_ sky130_fd_sc_hd__clkbuf_1
X_2666_ tree_instances\[19\].u_tree.pipeline_current_node\[0\]\[5\] VGND VGND VPWR
+ VPWR _1988_ sky130_fd_sc_hd__clkbuf_1
X_4405_ clknet_leaf_20_clk _0152_ net11 VGND VGND VPWR VPWR tree_instances\[1\].u_tree.pipeline_current_node\[0\]\[5\]
+ sky130_fd_sc_hd__dfrtp_1
X_4336_ clknet_leaf_17_clk _0049_ net11 VGND VGND VPWR VPWR tree_instances\[12\].u_tree.tree_state\[3\]
+ sky130_fd_sc_hd__dfrtp_1
X_2597_ _1901_ _1902_ VGND VGND VPWR VPWR _1929_ sky130_fd_sc_hd__nor2_1
XFILLER_0_1_284 VPWR VGND VPWR VGND sky130_ef_sc_hd__decap_12
X_4267_ tree_instances\[19\].u_tree.pipeline_frame_id\[0\]\[4\] tree_instances\[0\].u_tree.frame_id_in\[4\]
+ _0022_ VGND VGND VPWR VPWR _1516_ sky130_fd_sc_hd__mux2_1
X_3218_ complete_votes\[0\] VGND VGND VPWR VPWR _0889_ sky130_fd_sc_hd__inv_2
X_4198_ _1480_ VGND VGND VPWR VPWR _0505_ sky130_fd_sc_hd__clkbuf_1
X_3149_ tree_instances\[12\].u_tree.frame_id_out\[3\] VGND VGND VPWR VPWR _0821_ sky130_fd_sc_hd__inv_2
XFILLER_0_96_305 VGND VGND VPWR VPWR sky130_fd_sc_hd__decap_3
XFILLER_0_96_349 VPWR VGND VPWR VGND sky130_ef_sc_hd__decap_12
XFILLER_0_82_81 VGND VGND VPWR VPWR sky130_fd_sc_hd__decap_3
XFILLER_0_49_210 VGND VGND VPWR VPWR sky130_fd_sc_hd__fill_1
XFILLER_0_37_405 VGND VGND VPWR VPWR sky130_fd_sc_hd__decap_6
XFILLER_0_92_533 VPWR VGND VPWR VGND sky130_ef_sc_hd__decap_12
XFILLER_0_37_449 VGND VGND VPWR VPWR sky130_fd_sc_hd__fill_1
XFILLER_0_52_408 VPWR VGND VPWR VGND sky130_ef_sc_hd__decap_12
XFILLER_0_60_496 VPWR VGND VPWR VGND sky130_ef_sc_hd__decap_12
XFILLER_0_1_3 VPWR VGND VPWR VGND sky130_ef_sc_hd__decap_12
XTAP_TAPCELL_ROW_5_261 VGND VPWR sky130_fd_sc_hd__tapvpwrvgnd_1
XANTENNA_clkbuf_leaf_64_clk_A clknet_3_1__leaf_clk VGND VGND VPWR VPWR sky130_fd_sc_hd__diode_2
XTAP_TAPCELL_ROW_86_1066 VGND VPWR sky130_fd_sc_hd__tapvpwrvgnd_1
XFILLER_0_62_29 VPWR VGND VPWR VGND sky130_ef_sc_hd__decap_12
XFILLER_0_28_416 VGND VGND VPWR VPWR sky130_fd_sc_hd__fill_1
XTAP_TAPCELL_ROW_31_517 VGND VPWR sky130_fd_sc_hd__tapvpwrvgnd_1
XANTENNA__4642__RESET_B tree_instances\[0\].u_tree.rst_n VGND VGND VPWR VPWR sky130_fd_sc_hd__diode_2
XFILLER_0_55_235 VGND VGND VPWR VPWR sky130_fd_sc_hd__fill_1
XFILLER_0_11_22 VGND VGND VPWR VPWR sky130_fd_sc_hd__decap_3
XFILLER_0_11_55 VGND VGND VPWR VPWR sky130_fd_sc_hd__fill_1
XFILLER_0_3_505 VPWR VGND VPWR VGND sky130_ef_sc_hd__decap_12
XFILLER_0_23_110 VGND VGND VPWR VPWR sky130_fd_sc_hd__fill_2
XFILLER_0_51_441 VGND VGND VPWR VPWR sky130_fd_sc_hd__decap_6
XFILLER_0_11_77 VGND VGND VPWR VPWR sky130_fd_sc_hd__fill_1
X_2520_ tree_instances\[13\].u_tree.pipeline_current_node\[0\]\[4\] VGND VGND VPWR
+ VPWR _1865_ sky130_fd_sc_hd__clkbuf_1
XFILLER_0_23_143 VGND VGND VPWR VPWR sky130_fd_sc_hd__decap_4
X_2451_ tree_instances\[10\].u_tree.pipeline_current_node\[0\]\[6\] tree_instances\[10\].u_tree.pipeline_current_node\[0\]\[7\]
+ VGND VGND VPWR VPWR _1804_ sky130_fd_sc_hd__nor2_1
XANTENNA_clkbuf_leaf_17_clk_A clknet_3_2__leaf_clk VGND VGND VPWR VPWR sky130_fd_sc_hd__diode_2
X_2382_ _1742_ VGND VGND VPWR VPWR _1743_ sky130_fd_sc_hd__clkbuf_1
X_4121_ _1426_ VGND VGND VPWR VPWR _1427_ sky130_fd_sc_hd__clkbuf_1
X_4052_ tree_instances\[15\].u_tree.pipeline_frame_id\[0\]\[2\] _0674_ _0014_ VGND
+ VGND VPWR VPWR _1388_ sky130_fd_sc_hd__mux2_1
X_3003_ _0676_ _0677_ VGND VGND VPWR VPWR _0113_ sky130_fd_sc_hd__nor2_1
XFILLER_0_36_85 VGND VGND VPWR VPWR sky130_fd_sc_hd__fill_2
XFILLER_0_78_338 VGND VGND VPWR VPWR sky130_fd_sc_hd__fill_1
XANTENNA__3209__A1 _0689_ VGND VGND VPWR VPWR sky130_fd_sc_hd__diode_2
XTAP_TAPCELL_ROW_47_683 VGND VPWR sky130_fd_sc_hd__tapvpwrvgnd_1
XFILLER_0_93_308 VPWR VGND VPWR VGND sky130_ef_sc_hd__decap_12
XTAP_TAPCELL_ROW_19_396 VGND VPWR sky130_fd_sc_hd__tapvpwrvgnd_1
XFILLER_0_19_405 VPWR VGND VPWR VGND sky130_ef_sc_hd__decap_12
XANTENNA__4383__RESET_B net10 VGND VGND VPWR VPWR sky130_fd_sc_hd__diode_2
X_3905_ tree_instances\[12\].u_tree.pipeline_frame_id\[0\]\[1\] _1124_ _0008_ VGND
+ VGND VPWR VPWR _1305_ sky130_fd_sc_hd__mux2_1
XFILLER_0_19_449 VPWR VGND VPWR VGND sky130_ef_sc_hd__decap_12
XANTENNA__2968__B1 _0649_ VGND VGND VPWR VPWR sky130_fd_sc_hd__diode_2
XFILLER_0_46_235 VGND VGND VPWR VPWR sky130_fd_sc_hd__fill_2
X_4885_ clknet_leaf_45_clk _0557_ net12 VGND VGND VPWR VPWR tree_instances\[20\].u_tree.pipeline_frame_id\[0\]\[1\]
+ sky130_fd_sc_hd__dfrtp_1
X_3836_ _2041_ _1255_ VGND VGND VPWR VPWR _1262_ sky130_fd_sc_hd__and2_1
XFILLER_0_34_419 VGND VGND VPWR VPWR sky130_fd_sc_hd__fill_1
XFILLER_0_14_110 VGND VGND VPWR VPWR sky130_fd_sc_hd__fill_2
XFILLER_0_6_365 VPWR VGND VPWR VGND sky130_ef_sc_hd__decap_12
XFILLER_0_27_493 VGND VGND VPWR VPWR sky130_fd_sc_hd__fill_1
XFILLER_0_42_430 VGND VGND VPWR VPWR sky130_fd_sc_hd__decap_4
X_3767_ _1225_ VGND VGND VPWR VPWR _0329_ sky130_fd_sc_hd__clkbuf_1
XFILLER_0_42_474 VGND VGND VPWR VPWR sky130_fd_sc_hd__fill_2
X_2718_ _1601_ VGND VGND VPWR VPWR _2034_ sky130_fd_sc_hd__clkbuf_1
X_3698_ _2086_ _1179_ VGND VGND VPWR VPWR _1186_ sky130_fd_sc_hd__and2_1
X_2649_ _1971_ VGND VGND VPWR VPWR _0015_ sky130_fd_sc_hd__clkbuf_1
XFILLER_0_10_371 VPWR VGND VPWR VGND sky130_ef_sc_hd__decap_12
X_4319_ _1542_ VGND VGND VPWR VPWR _0564_ sky130_fd_sc_hd__clkbuf_1
XANTENNA__4441__SET_B net13 VGND VGND VPWR VPWR sky130_fd_sc_hd__diode_2
XTAP_TAPCELL_ROW_2_231 VGND VPWR sky130_fd_sc_hd__tapvpwrvgnd_1
XFILLER_0_96_113 VPWR VGND VPWR VGND sky130_ef_sc_hd__decap_12
XFILLER_0_77_393 VPWR VGND VPWR VGND sky130_ef_sc_hd__decap_12
XFILLER_0_9_192 VGND VGND VPWR VPWR sky130_fd_sc_hd__fill_2
XFILLER_0_80_569 VGND VGND VPWR VPWR sky130_fd_sc_hd__decap_4
XFILLER_0_52_227 VPWR VGND VPWR VGND sky130_ef_sc_hd__decap_12
XANTENNA__4823__RESET_B net10 VGND VGND VPWR VPWR sky130_fd_sc_hd__diode_2
XFILLER_0_87_113 VGND VGND VPWR VPWR sky130_fd_sc_hd__decap_3
XTAP_TAPCELL_ROW_16_366 VGND VPWR sky130_fd_sc_hd__tapvpwrvgnd_1
XTAP_TAPCELL_ROW_44_653 VGND VPWR sky130_fd_sc_hd__tapvpwrvgnd_1
XFILLER_0_56_511 VPWR VGND VPWR VGND sky130_ef_sc_hd__decap_12
XFILLER_0_95_190 VPWR VGND VPWR VGND sky130_ef_sc_hd__decap_12
XFILLER_0_83_330 VGND VGND VPWR VPWR sky130_fd_sc_hd__fill_1
XFILLER_0_22_32 VGND VGND VPWR VPWR sky130_fd_sc_hd__fill_2
XFILLER_0_83_385 VGND VGND VPWR VPWR sky130_fd_sc_hd__fill_2
XFILLER_0_83_374 VGND VGND VPWR VPWR sky130_fd_sc_hd__fill_1
XFILLER_0_71_514 VPWR VGND VPWR VGND sky130_ef_sc_hd__decap_12
XFILLER_0_43_216 VGND VGND VPWR VPWR sky130_fd_sc_hd__fill_1
X_4670_ clknet_leaf_12_clk _0375_ tree_instances\[0\].u_tree.rst_n VGND VGND VPWR
+ VPWR tree_instances\[11\].u_tree.frame_id_out\[4\] sky130_fd_sc_hd__dfrtp_1
X_3621_ _1832_ _1135_ _0002_ tree_instances\[0\].u_tree.pipeline_valid\[0\] VGND VGND
+ VPWR VPWR _0273_ sky130_fd_sc_hd__o2bb2a_1
XFILLER_0_3_335 VGND VGND VPWR VPWR sky130_fd_sc_hd__fill_1
X_3552_ _1770_ _1089_ _0624_ tree_instances\[5\].u_tree.ready_for_next VGND VGND VPWR
+ VPWR _0250_ sky130_fd_sc_hd__a22o_1
XFILLER_0_11_113 VPWR VGND VPWR VGND sky130_ef_sc_hd__decap_12
XFILLER_0_11_102 VGND VGND VPWR VPWR sky130_fd_sc_hd__decap_8
X_2503_ tree_instances\[3\].u_tree.pipeline_current_node\[0\]\[2\] VGND VGND VPWR
+ VPWR _1849_ sky130_fd_sc_hd__clkbuf_1
X_3483_ _1045_ VGND VGND VPWR VPWR _0225_ sky130_fd_sc_hd__clkbuf_1
X_2434_ tree_instances\[16\].u_tree.pipeline_current_node\[0\]\[7\] VGND VGND VPWR
+ VPWR _1788_ sky130_fd_sc_hd__clkbuf_1
X_2365_ _1727_ VGND VGND VPWR VPWR _1728_ sky130_fd_sc_hd__clkbuf_1
XFILLER_0_47_62 VGND VGND VPWR VPWR sky130_fd_sc_hd__decap_8
X_4104_ tree_instances\[16\].u_tree.frame_id_out\[1\] tree_instances\[16\].u_tree.pipeline_frame_id\[0\]\[1\]
+ _1729_ VGND VGND VPWR VPWR _1415_ sky130_fd_sc_hd__mux2_1
X_2296_ _1574_ VGND VGND VPWR VPWR _1666_ sky130_fd_sc_hd__clkbuf_4
X_4035_ _1379_ VGND VGND VPWR VPWR _0443_ sky130_fd_sc_hd__clkbuf_1
XANTENNA__4564__RESET_B net9 VGND VGND VPWR VPWR sky130_fd_sc_hd__diode_2
XFILLER_0_78_135 VGND VGND VPWR VPWR sky130_fd_sc_hd__decap_4
XFILLER_0_2_53 VGND VGND VPWR VPWR sky130_fd_sc_hd__decap_8
XANTENNA__3850__A1 _1192_ VGND VGND VPWR VPWR sky130_fd_sc_hd__diode_2
XANTENNA__3602__A1 _0675_ VGND VGND VPWR VPWR sky130_fd_sc_hd__diode_2
XFILLER_0_59_393 VPWR VGND VPWR VGND sky130_ef_sc_hd__decap_12
X_4868_ clknet_leaf_33_clk _0022_ net10 VGND VGND VPWR VPWR tree_instances\[19\].u_tree.tree_state\[2\]
+ sky130_fd_sc_hd__dfrtp_1
XFILLER_0_74_374 VGND VGND VPWR VPWR sky130_fd_sc_hd__fill_1
XFILLER_0_62_525 VGND VGND VPWR VPWR sky130_fd_sc_hd__decap_3
XFILLER_0_19_279 VGND VGND VPWR VPWR sky130_fd_sc_hd__fill_1
X_3819_ tree_instances\[7\].u_tree.tree_state\[3\] _0616_ VGND VGND VPWR VPWR _1252_
+ sky130_fd_sc_hd__nor2_1
X_4799_ clknet_leaf_53_clk _0486_ tree_instances\[0\].u_tree.rst_n VGND VGND VPWR
+ VPWR tree_instances\[17\].u_tree.pipeline_current_node\[0\]\[3\] sky130_fd_sc_hd__dfrtp_1
XFILLER_0_30_400 VGND VGND VPWR VPWR sky130_fd_sc_hd__fill_2
XFILLER_0_30_477 VGND VGND VPWR VPWR sky130_fd_sc_hd__fill_2
XFILLER_0_30_499 VPWR VGND VPWR VGND sky130_ef_sc_hd__decap_12
XANTENNA__4094__A1 _0672_ VGND VGND VPWR VPWR sky130_fd_sc_hd__diode_2
XTAP_TAPCELL_ROW_58_789 VGND VPWR sky130_fd_sc_hd__tapvpwrvgnd_1
XTAP_TAPCELL_ROW_83_1036 VGND VPWR sky130_fd_sc_hd__tapvpwrvgnd_1
XFILLER_0_65_341 VGND VGND VPWR VPWR sky130_fd_sc_hd__fill_2
XTAP_TAPCELL_ROW_41_623 VGND VPWR sky130_fd_sc_hd__tapvpwrvgnd_1
XTAP_TAPCELL_ROW_13_336 VGND VPWR sky130_fd_sc_hd__tapvpwrvgnd_1
XFILLER_0_80_322 VGND VGND VPWR VPWR sky130_fd_sc_hd__fill_2
XFILLER_0_25_238 VPWR VGND VPWR VGND sky130_ef_sc_hd__decap_12
XFILLER_0_53_558 VGND VGND VPWR VPWR sky130_fd_sc_hd__fill_2
XFILLER_0_80_355 VGND VGND VPWR VPWR sky130_fd_sc_hd__fill_2
XFILLER_0_18_290 VGND VGND VPWR VPWR sky130_fd_sc_hd__decap_8
XFILLER_0_21_422 VGND VGND VPWR VPWR sky130_fd_sc_hd__decap_3
XFILLER_0_0_305 VGND VGND VPWR VPWR sky130_fd_sc_hd__decap_3
XFILLER_0_0_349 VPWR VGND VPWR VGND sky130_ef_sc_hd__decap_12
XANTENNA__3018__A _0689_ VGND VGND VPWR VPWR sky130_fd_sc_hd__diode_2
XFILLER_0_84_27 VGND VGND VPWR VPWR sky130_fd_sc_hd__fill_1
XTAP_TAPCELL_ROW_49_701 VGND VPWR sky130_fd_sc_hd__tapvpwrvgnd_1
X_2983_ _0660_ VGND VGND VPWR VPWR _0661_ sky130_fd_sc_hd__clkbuf_4
XFILLER_0_29_533 VPWR VGND VPWR VGND sky130_ef_sc_hd__decap_12
XFILLER_0_56_330 VGND VGND VPWR VPWR sky130_fd_sc_hd__decap_8
X_4722_ clknet_leaf_35_clk _0420_ net10 VGND VGND VPWR VPWR tree_instances\[14\].u_tree.pipeline_current_node\[0\]\[0\]
+ sky130_fd_sc_hd__dfrtp_1
XFILLER_0_33_97 VPWR VGND VPWR VGND sky130_ef_sc_hd__decap_12
XFILLER_0_56_374 VGND VGND VPWR VPWR sky130_fd_sc_hd__fill_2
XFILLER_0_56_396 VGND VGND VPWR VPWR sky130_fd_sc_hd__fill_2
XFILLER_0_71_344 VGND VGND VPWR VPWR sky130_fd_sc_hd__fill_2
XFILLER_0_3_110 VGND VGND VPWR VPWR sky130_fd_sc_hd__fill_2
X_4653_ clknet_leaf_12_clk _0358_ tree_instances\[0\].u_tree.rst_n VGND VGND VPWR
+ VPWR tree_instances\[11\].u_tree.pipeline_current_node\[0\]\[1\] sky130_fd_sc_hd__dfrtp_1
X_3604_ tree_instances\[6\].u_tree.pipeline_frame_id\[0\]\[3\] _0925_ _0036_ VGND
+ VGND VPWR VPWR _1127_ sky130_fd_sc_hd__mux2_1
X_4584_ clknet_leaf_8_clk _0304_ net12 VGND VGND VPWR VPWR tree_instances\[8\].u_tree.pipeline_frame_id\[0\]\[1\]
+ sky130_fd_sc_hd__dfrtp_1
X_3535_ tree_instances\[5\].u_tree.pipeline_frame_id\[0\]\[2\] _0675_ _0034_ VGND
+ VGND VPWR VPWR _1081_ sky130_fd_sc_hd__mux2_1
XFILLER_0_12_466 VGND VGND VPWR VPWR sky130_fd_sc_hd__fill_2
X_3466_ tree_instances\[4\].u_tree.pipeline_current_node\[0\]\[7\] _1028_ VGND VGND
+ VPWR VPWR _1037_ sky130_fd_sc_hd__and2_1
X_2417_ tree_instances\[5\].u_tree.tree_state\[0\] _1771_ VGND VGND VPWR VPWR _1772_
+ sky130_fd_sc_hd__and2_1
X_3397_ _0995_ VGND VGND VPWR VPWR _0996_ sky130_fd_sc_hd__dlymetal6s2s_1
XFILLER_0_42_3 VGND VGND VPWR VPWR sky130_fd_sc_hd__decap_4
XANTENNA__4745__RESET_B net10 VGND VGND VPWR VPWR sky130_fd_sc_hd__diode_2
X_2348_ _1711_ VGND VGND VPWR VPWR _1712_ sky130_fd_sc_hd__inv_2
X_2279_ tree_instances\[8\].u_tree.pipeline_current_node\[0\]\[1\] VGND VGND VPWR
+ VPWR _1650_ sky130_fd_sc_hd__clkbuf_1
X_4018_ _1370_ VGND VGND VPWR VPWR _0435_ sky130_fd_sc_hd__clkbuf_1
XFILLER_0_79_477 VGND VGND VPWR VPWR sky130_fd_sc_hd__decap_6
XTAP_TAPCELL_ROW_55_759 VGND VPWR sky130_fd_sc_hd__tapvpwrvgnd_1
XFILLER_0_90_70 VPWR VGND VPWR VGND sky130_ef_sc_hd__decap_12
XFILLER_0_90_92 VPWR VGND VPWR VGND sky130_ef_sc_hd__decap_12
XFILLER_0_47_374 VGND VGND VPWR VPWR sky130_fd_sc_hd__decap_6
XTAP_TAPCELL_ROW_10_306 VGND VPWR sky130_fd_sc_hd__tapvpwrvgnd_1
XFILLER_0_35_558 VGND VGND VPWR VPWR sky130_fd_sc_hd__fill_2
XFILLER_0_15_260 VGND VGND VPWR VPWR sky130_fd_sc_hd__fill_2
XANTENNA__4486__RESET_B tree_instances\[0\].u_tree.rst_n VGND VGND VPWR VPWR sky130_fd_sc_hd__diode_2
XANTENNA__4415__RESET_B net11 VGND VGND VPWR VPWR sky130_fd_sc_hd__diode_2
XFILLER_0_85_447 VGND VGND VPWR VPWR sky130_fd_sc_hd__fill_1
XFILLER_0_70_29 VPWR VGND VPWR VGND sky130_ef_sc_hd__decap_12
XTAP_TAPCELL_ROW_26_472 VGND VPWR sky130_fd_sc_hd__tapvpwrvgnd_1
XFILLER_0_65_182 VPWR VGND VPWR VGND sky130_ef_sc_hd__decap_12
XFILLER_0_5_408 VPWR VGND VPWR VGND sky130_ef_sc_hd__decap_12
XFILLER_0_80_141 VGND VGND VPWR VPWR sky130_fd_sc_hd__decap_3
XFILLER_0_80_130 VGND VGND VPWR VPWR sky130_fd_sc_hd__decap_8
XFILLER_0_80_185 VGND VGND VPWR VPWR sky130_fd_sc_hd__fill_1
XFILLER_0_80_163 VPWR VGND VPWR VGND sky130_ef_sc_hd__decap_12
XFILLER_0_79_49 VGND VGND VPWR VPWR sky130_fd_sc_hd__decap_3
XFILLER_0_41_528 VPWR VGND VPWR VGND sky130_ef_sc_hd__decap_12
X_3320_ tree_instances\[1\].u_tree.pipeline_frame_id\[0\]\[3\] _0925_ _0024_ VGND
+ VGND VPWR VPWR _0949_ sky130_fd_sc_hd__mux2_1
XFILLER_0_0_113 VPWR VGND VPWR VGND sky130_ef_sc_hd__decap_12
XFILLER_0_95_15 VPWR VGND VPWR VGND sky130_ef_sc_hd__decap_12
X_3251_ _2129_ _0912_ VGND VGND VPWR VPWR _0913_ sky130_fd_sc_hd__and2_1
X_3182_ _0726_ tree_instances\[8\].u_tree.frame_id_out\[0\] VGND VGND VPWR VPWR _0854_
+ sky130_fd_sc_hd__xor2_1
X_2202_ _1581_ VGND VGND VPWR VPWR _1582_ sky130_fd_sc_hd__inv_2
XFILLER_0_28_42 VGND VGND VPWR VPWR sky130_fd_sc_hd__fill_1
XFILLER_0_44_41 VPWR VGND VPWR VGND sky130_ef_sc_hd__decap_12
XFILLER_0_44_85 VGND VGND VPWR VPWR sky130_fd_sc_hd__decap_8
XTAP_TAPCELL_ROW_52_729 VGND VPWR sky130_fd_sc_hd__tapvpwrvgnd_1
XFILLER_0_91_428 VPWR VGND VPWR VGND sky130_ef_sc_hd__decap_12
XFILLER_0_63_119 VGND VGND VPWR VPWR sky130_fd_sc_hd__fill_1
XFILLER_0_17_503 VGND VGND VPWR VPWR sky130_fd_sc_hd__fill_1
XFILLER_0_84_480 VGND VGND VPWR VPWR sky130_fd_sc_hd__fill_2
X_2966_ _0647_ VGND VGND VPWR VPWR _0648_ sky130_fd_sc_hd__clkbuf_4
XFILLER_0_56_160 VGND VGND VPWR VPWR sky130_fd_sc_hd__fill_2
X_2897_ _0602_ VGND VGND VPWR VPWR _0010_ sky130_fd_sc_hd__inv_2
X_4705_ clknet_leaf_5_clk _0408_ net9 VGND VGND VPWR VPWR tree_instances\[13\].u_tree.pipeline_frame_id\[0\]\[0\]
+ sky130_fd_sc_hd__dfrtp_1
XFILLER_0_71_185 VGND VGND VPWR VPWR sky130_fd_sc_hd__decap_4
XFILLER_0_8_41 VGND VGND VPWR VPWR sky130_fd_sc_hd__decap_8
X_4636_ clknet_leaf_11_clk _0346_ tree_instances\[0\].u_tree.rst_n VGND VGND VPWR
+ VPWR tree_instances\[10\].u_tree.pipeline_frame_id\[0\]\[2\] sky130_fd_sc_hd__dfrtp_1
X_4567_ clknet_leaf_5_clk _0288_ tree_instances\[0\].u_tree.rst_n VGND VGND VPWR VPWR
+ tree_instances\[7\].u_tree.frame_id_out\[0\] sky130_fd_sc_hd__dfrtp_1
XFILLER_0_40_572 VGND VGND VPWR VPWR sky130_fd_sc_hd__fill_2
X_3518_ _1070_ VGND VGND VPWR VPWR _0235_ sky130_fd_sc_hd__clkbuf_1
X_4498_ clknet_leaf_3_clk _0004_ tree_instances\[0\].u_tree.rst_n VGND VGND VPWR VPWR
+ tree_instances\[10\].u_tree.tree_state\[2\] sky130_fd_sc_hd__dfrtp_1
X_3449_ _1577_ _1027_ _0010_ tree_instances\[13\].u_tree.pipeline_valid\[0\] VGND
+ VGND VPWR VPWR _0209_ sky130_fd_sc_hd__o2bb2a_1
XTAP_TAPCELL_ROW_68_884 VGND VPWR sky130_fd_sc_hd__tapvpwrvgnd_1
XTAP_TAPCELL_ROW_80_1006 VGND VPWR sky130_fd_sc_hd__tapvpwrvgnd_1
XANTENNA__3121__A _0661_ VGND VGND VPWR VPWR sky130_fd_sc_hd__diode_2
XFILLER_0_82_406 VPWR VGND VPWR VGND sky130_ef_sc_hd__decap_12
XTAP_TAPCELL_ROW_23_442 VGND VPWR sky130_fd_sc_hd__tapvpwrvgnd_1
XANTENNA__4221__A1 tree_instances\[0\].u_tree.frame_id_in\[4\] VGND VGND VPWR VPWR
+ sky130_fd_sc_hd__diode_2
XFILLER_0_62_141 VGND VGND VPWR VPWR sky130_fd_sc_hd__decap_8
XFILLER_0_62_130 VGND VGND VPWR VPWR sky130_fd_sc_hd__decap_8
XFILLER_0_35_344 VGND VGND VPWR VPWR sky130_fd_sc_hd__fill_2
XFILLER_0_90_483 VPWR VGND VPWR VGND sky130_ef_sc_hd__decap_12
XFILLER_0_90_461 VGND VGND VPWR VPWR sky130_fd_sc_hd__decap_6
XFILLER_0_23_517 VPWR VGND VPWR VGND sky130_ef_sc_hd__decap_12
XFILLER_0_31_572 VGND VGND VPWR VPWR sky130_fd_sc_hd__fill_2
XFILLER_0_50_369 VGND VGND VPWR VPWR sky130_fd_sc_hd__fill_2
XANTENNA__4667__RESET_B tree_instances\[0\].u_tree.rst_n VGND VGND VPWR VPWR sky130_fd_sc_hd__diode_2
XTAP_TAPCELL_ROW_89_1097 VGND VPWR sky130_fd_sc_hd__tapvpwrvgnd_1
XFILLER_0_81_39 VGND VGND VPWR VPWR sky130_fd_sc_hd__fill_2
XFILLER_0_58_425 VPWR VGND VPWR VGND sky130_ef_sc_hd__decap_12
XANTENNA__3031__A _0653_ VGND VGND VPWR VPWR sky130_fd_sc_hd__diode_2
XFILLER_0_85_266 VPWR VGND VPWR VGND sky130_ef_sc_hd__decap_12
XFILLER_0_73_439 VGND VGND VPWR VPWR sky130_fd_sc_hd__decap_3
XFILLER_0_14_88 VPWR VGND VPWR VGND sky130_ef_sc_hd__decap_12
X_2820_ _2119_ VGND VGND VPWR VPWR _2124_ sky130_fd_sc_hd__clkbuf_1
XFILLER_0_26_333 VGND VGND VPWR VPWR sky130_fd_sc_hd__fill_2
X_2751_ tree_instances\[16\].u_tree.pipeline_current_node\[0\]\[8\] VGND VGND VPWR
+ VPWR _2062_ sky130_fd_sc_hd__clkbuf_1
XFILLER_0_53_141 VGND VGND VPWR VPWR sky130_fd_sc_hd__fill_2
XFILLER_0_81_461 VPWR VGND VPWR VGND sky130_ef_sc_hd__decap_12
X_2682_ tree_instances\[13\].u_tree.pipeline_current_node\[0\]\[8\] VGND VGND VPWR
+ VPWR _2003_ sky130_fd_sc_hd__clkbuf_1
XFILLER_0_26_377 VPWR VGND VPWR VGND sky130_ef_sc_hd__decap_12
X_4421_ clknet_leaf_42_clk _0167_ net10 VGND VGND VPWR VPWR tree_instances\[15\].u_tree.pipeline_valid\[0\]
+ sky130_fd_sc_hd__dfrtp_1
XFILLER_0_1_433 VPWR VGND VPWR VGND sky130_ef_sc_hd__decap_12
XFILLER_0_22_550 VPWR VGND VPWR VGND sky130_ef_sc_hd__decap_12
X_4352_ clknet_leaf_27_clk _0112_ net11 VGND VGND VPWR VPWR tree_instances\[0\].u_tree.frame_id_in\[1\]
+ sky130_fd_sc_hd__dfrtp_1
XFILLER_0_39_41 VPWR VGND VPWR VGND sky130_ef_sc_hd__decap_12
X_3303_ _0940_ VGND VGND VPWR VPWR _0150_ sky130_fd_sc_hd__clkbuf_1
X_4283_ _1523_ VGND VGND VPWR VPWR _1524_ sky130_fd_sc_hd__buf_1
X_3234_ state\[1\] state\[0\] complete_votes\[3\] VGND VGND VPWR VPWR _0903_ sky130_fd_sc_hd__and3_1
X_3165_ _0702_ tree_instances\[11\].u_tree.frame_id_out\[3\] tree_instances\[11\].u_tree.frame_id_out\[4\]
+ _0696_ _0836_ VGND VGND VPWR VPWR _0837_ sky130_fd_sc_hd__o221a_1
X_3096_ tree_instances\[1\].u_tree.frame_id_out\[1\] VGND VGND VPWR VPWR _0768_ sky130_fd_sc_hd__inv_2
XFILLER_0_55_73 VGND VGND VPWR VPWR sky130_fd_sc_hd__decap_4
XFILLER_0_89_561 VPWR VGND VPWR VGND sky130_ef_sc_hd__decap_12
XTAP_TAPCELL_ROW_65_854 VGND VPWR sky130_fd_sc_hd__tapvpwrvgnd_1
XTAP_TAPCELL_ROW_37_578 VGND VPWR sky130_fd_sc_hd__tapvpwrvgnd_1
XFILLER_0_49_436 VGND VGND VPWR VPWR sky130_fd_sc_hd__decap_4
XFILLER_0_49_447 VGND VGND VPWR VPWR sky130_fd_sc_hd__fill_1
XFILLER_0_49_458 VPWR VGND VPWR VGND sky130_ef_sc_hd__decap_12
XFILLER_0_64_417 VGND VGND VPWR VPWR sky130_fd_sc_hd__decap_3
XFILLER_0_91_225 VPWR VGND VPWR VGND sky130_ef_sc_hd__decap_12
XFILLER_0_76_288 VGND VGND VPWR VPWR sky130_fd_sc_hd__fill_2
X_3998_ _1360_ VGND VGND VPWR VPWR _0425_ sky130_fd_sc_hd__clkbuf_1
XFILLER_0_17_322 VPWR VGND VPWR VGND sky130_ef_sc_hd__decap_12
XANTENNA__4769__SET_B net10 VGND VGND VPWR VPWR sky130_fd_sc_hd__diode_2
X_2949_ _0635_ _1888_ VGND VGND VPWR VPWR _0636_ sky130_fd_sc_hd__or2_1
XTAP_TAPCELL_ROW_20_412 VGND VPWR sky130_fd_sc_hd__tapvpwrvgnd_1
XFILLER_0_29_193 VPWR VGND VPWR VGND sky130_ef_sc_hd__decap_12
XFILLER_0_44_141 VGND VGND VPWR VPWR sky130_fd_sc_hd__decap_8
XFILLER_0_32_303 VGND VGND VPWR VPWR sky130_fd_sc_hd__fill_2
XFILLER_0_13_561 VPWR VGND VPWR VGND sky130_ef_sc_hd__decap_12
X_4619_ clknet_leaf_6_clk _0105_ tree_instances\[0\].u_tree.rst_n VGND VGND VPWR VPWR
+ tree_instances\[9\].u_tree.prediction_valid sky130_fd_sc_hd__dfrtp_1
XANTENNA__4760__RESET_B net10 VGND VGND VPWR VPWR sky130_fd_sc_hd__diode_2
XANTENNA__4132__A1_N _1908_ VGND VGND VPWR VPWR sky130_fd_sc_hd__diode_2
XFILLER_0_67_233 VGND VGND VPWR VPWR sky130_fd_sc_hd__decap_3
XFILLER_0_95_553 VGND VGND VPWR VPWR sky130_fd_sc_hd__decap_6
XFILLER_0_55_417 VGND VGND VPWR VPWR sky130_fd_sc_hd__decap_6
XANTENNA__4848__RESET_B net10 VGND VGND VPWR VPWR sky130_fd_sc_hd__diode_2
XFILLER_0_63_461 VPWR VGND VPWR VGND sky130_ef_sc_hd__decap_12
Xclkload29 clknet_leaf_18_clk VGND VGND VPWR VPWR clkload29/Y sky130_fd_sc_hd__bufinv_16
Xclkload18 clknet_leaf_65_clk VGND VGND VPWR VPWR clkload18/Y sky130_fd_sc_hd__inv_6
XFILLER_0_50_133 VGND VGND VPWR VPWR sky130_fd_sc_hd__decap_6
XANTENNA__4767__D _0026_ VGND VGND VPWR VPWR sky130_fd_sc_hd__diode_2
XANTENNA__4430__RESET_B net9 VGND VGND VPWR VPWR sky130_fd_sc_hd__diode_2
XTAP_TAPCELL_ROW_8_292 VGND VPWR sky130_fd_sc_hd__tapvpwrvgnd_1
XFILLER_0_92_27 VGND VGND VPWR VPWR sky130_fd_sc_hd__fill_1
XTAP_TAPCELL_ROW_62_824 VGND VPWR sky130_fd_sc_hd__tapvpwrvgnd_1
XFILLER_0_58_222 VPWR VGND VPWR VGND sky130_ef_sc_hd__decap_12
XFILLER_0_25_76 VGND VGND VPWR VPWR sky130_fd_sc_hd__decap_6
X_3921_ tree_instances\[12\].u_tree.frame_id_out\[4\] tree_instances\[12\].u_tree.pipeline_frame_id\[0\]\[4\]
+ tree_instances\[12\].u_tree.tree_state\[3\] VGND VGND VPWR VPWR _1313_ sky130_fd_sc_hd__mux2_1
XTAP_TAPCELL_ROW_34_548 VGND VPWR sky130_fd_sc_hd__tapvpwrvgnd_1
XFILLER_0_46_406 VPWR VGND VPWR VGND sky130_ef_sc_hd__decap_12
XFILLER_0_73_225 VGND VGND VPWR VPWR sky130_fd_sc_hd__fill_2
XFILLER_0_58_277 VPWR VGND VPWR VGND sky130_ef_sc_hd__decap_12
X_3852_ tree_instances\[11\].u_tree.pipeline_frame_id\[0\]\[4\] _1168_ _0006_ VGND
+ VGND VPWR VPWR _1270_ sky130_fd_sc_hd__mux2_1
XFILLER_0_6_525 VGND VGND VPWR VPWR sky130_fd_sc_hd__decap_6
X_2803_ _1844_ VGND VGND VPWR VPWR _2107_ sky130_fd_sc_hd__clkbuf_1
XFILLER_0_41_42 VGND VGND VPWR VPWR sky130_fd_sc_hd__fill_2
XANTENNA__4589__RESET_B net12 VGND VGND VPWR VPWR sky130_fd_sc_hd__diode_2
XFILLER_0_6_569 VGND VGND VPWR VPWR sky130_fd_sc_hd__decap_4
XFILLER_0_26_141 VGND VGND VPWR VPWR sky130_fd_sc_hd__fill_1
XFILLER_0_26_163 VGND VGND VPWR VPWR sky130_fd_sc_hd__fill_2
X_3783_ _1234_ VGND VGND VPWR VPWR _0336_ sky130_fd_sc_hd__clkbuf_1
XFILLER_0_54_450 VPWR VGND VPWR VGND sky130_ef_sc_hd__decap_12
XANTENNA__4518__RESET_B net12 VGND VGND VPWR VPWR sky130_fd_sc_hd__diode_2
XFILLER_0_41_100 VGND VGND VPWR VPWR sky130_fd_sc_hd__fill_2
XFILLER_0_41_122 VGND VGND VPWR VPWR sky130_fd_sc_hd__fill_2
X_2734_ tree_instances\[10\].u_tree.prediction_valid _1597_ VGND VGND VPWR VPWR _2046_
+ sky130_fd_sc_hd__and2b_1
X_2665_ tree_instances\[19\].u_tree.pipeline_current_node\[0\]\[6\] VGND VGND VPWR
+ VPWR _1987_ sky130_fd_sc_hd__clkbuf_1
X_4404_ clknet_leaf_20_clk _0151_ net11 VGND VGND VPWR VPWR tree_instances\[1\].u_tree.pipeline_current_node\[0\]\[4\]
+ sky130_fd_sc_hd__dfrtp_1
X_2596_ tree_instances\[20\].u_tree.pipeline_current_node\[0\]\[1\] tree_instances\[20\].u_tree.pipeline_current_node\[0\]\[0\]
+ VGND VGND VPWR VPWR _1928_ sky130_fd_sc_hd__nor2_1
XFILLER_0_41_199 VPWR VGND VPWR VGND sky130_ef_sc_hd__decap_12
X_4335_ clknet_leaf_18_clk _0008_ net11 VGND VGND VPWR VPWR tree_instances\[12\].u_tree.tree_state\[2\]
+ sky130_fd_sc_hd__dfrtp_1
XFILLER_0_1_296 VPWR VGND VPWR VGND sky130_ef_sc_hd__decap_12
X_4266_ _1515_ VGND VGND VPWR VPWR _0538_ sky130_fd_sc_hd__clkbuf_1
X_3217_ _0887_ _0000_ VGND VGND VPWR VPWR _0888_ sky130_fd_sc_hd__nor2_1
X_4197_ _1429_ _1478_ VGND VGND VPWR VPWR _1480_ sky130_fd_sc_hd__and2_1
XTAP_TAPCELL_ROW_78_990 VGND VPWR sky130_fd_sc_hd__tapvpwrvgnd_1
X_3148_ _0662_ tree_instances\[12\].u_tree.frame_id_out\[4\] VGND VGND VPWR VPWR _0820_
+ sky130_fd_sc_hd__xnor2_1
XFILLER_0_69_509 VGND VGND VPWR VPWR sky130_fd_sc_hd__fill_1
XFILLER_0_49_200 VGND VGND VPWR VPWR sky130_fd_sc_hd__fill_2
X_3079_ _0685_ tree_instances\[19\].u_tree.frame_id_out\[1\] _0749_ _0657_ _0750_
+ VGND VGND VPWR VPWR _0751_ sky130_fd_sc_hd__o221a_1
XFILLER_0_49_233 VGND VGND VPWR VPWR sky130_fd_sc_hd__decap_4
XFILLER_0_64_225 VGND VGND VPWR VPWR sky130_fd_sc_hd__decap_3
XFILLER_0_49_277 VGND VGND VPWR VPWR sky130_fd_sc_hd__decap_3
XFILLER_0_92_545 VPWR VGND VPWR VGND sky130_ef_sc_hd__decap_12
XFILLER_0_17_141 VGND VGND VPWR VPWR sky130_fd_sc_hd__decap_3
XFILLER_0_45_461 VPWR VGND VPWR VGND sky130_ef_sc_hd__decap_12
XFILLER_0_32_111 VGND VGND VPWR VPWR sky130_fd_sc_hd__fill_2
XFILLER_0_60_475 VGND VGND VPWR VPWR sky130_fd_sc_hd__fill_1
XFILLER_0_13_391 VGND VGND VPWR VPWR sky130_fd_sc_hd__fill_1
XANTENNA__3163__A1 _0697_ VGND VGND VPWR VPWR sky130_fd_sc_hd__diode_2
XTAP_TAPCELL_ROW_5_262 VGND VPWR sky130_fd_sc_hd__tapvpwrvgnd_1
XTAP_TAPCELL_ROW_86_1067 VGND VPWR sky130_fd_sc_hd__tapvpwrvgnd_1
XFILLER_0_95_361 VGND VGND VPWR VPWR sky130_fd_sc_hd__fill_1
XFILLER_0_83_501 VGND VGND VPWR VPWR sky130_fd_sc_hd__fill_1
XFILLER_0_55_225 VGND VGND VPWR VPWR sky130_fd_sc_hd__fill_2
XTAP_TAPCELL_ROW_31_518 VGND VPWR sky130_fd_sc_hd__tapvpwrvgnd_1
XANTENNA__4682__RESET_B net11 VGND VGND VPWR VPWR sky130_fd_sc_hd__diode_2
XFILLER_0_70_239 VGND VGND VPWR VPWR sky130_fd_sc_hd__decap_4
XFILLER_0_11_45 VGND VGND VPWR VPWR sky130_fd_sc_hd__fill_2
XFILLER_0_3_517 VPWR VGND VPWR VGND sky130_ef_sc_hd__decap_12
XANTENNA__4611__RESET_B tree_instances\[0\].u_tree.rst_n VGND VGND VPWR VPWR sky130_fd_sc_hd__diode_2
XANTENNA__3108__A2_N _0646_ VGND VGND VPWR VPWR sky130_fd_sc_hd__diode_2
XFILLER_0_23_166 VGND VGND VPWR VPWR sky130_fd_sc_hd__fill_2
X_2450_ _1799_ _1802_ VGND VGND VPWR VPWR _1803_ sky130_fd_sc_hd__nor2_1
X_2381_ _1741_ tree_instances\[14\].u_tree.pipeline_current_node\[0\]\[0\] VGND VGND
+ VPWR VPWR _1742_ sky130_fd_sc_hd__or2_1
X_4120_ _1422_ VGND VGND VPWR VPWR _1426_ sky130_fd_sc_hd__clkbuf_1
X_4051_ _1387_ VGND VGND VPWR VPWR _0451_ sky130_fd_sc_hd__clkbuf_1
X_3002_ tree_instances\[0\].u_tree.frame_id_in\[1\] tree_instances\[0\].u_tree.frame_id_in\[2\]
+ _0671_ VGND VGND VPWR VPWR _0677_ sky130_fd_sc_hd__and3_1
XTAP_TAPCELL_ROW_75_960 VGND VPWR sky130_fd_sc_hd__tapvpwrvgnd_1
XTAP_TAPCELL_ROW_19_397 VGND VPWR sky130_fd_sc_hd__tapvpwrvgnd_1
X_3904_ _1304_ VGND VGND VPWR VPWR _0387_ sky130_fd_sc_hd__clkbuf_1
XFILLER_0_19_417 VPWR VGND VPWR VGND sky130_ef_sc_hd__decap_12
XFILLER_0_74_545 VGND VGND VPWR VPWR sky130_fd_sc_hd__fill_1
X_4884_ clknet_leaf_45_clk _0556_ net12 VGND VGND VPWR VPWR tree_instances\[20\].u_tree.pipeline_frame_id\[0\]\[0\]
+ sky130_fd_sc_hd__dfrtp_1
X_3835_ _1261_ VGND VGND VPWR VPWR _0361_ sky130_fd_sc_hd__clkbuf_1
XFILLER_0_27_461 VPWR VGND VPWR VGND sky130_ef_sc_hd__decap_12
XANTENNA__4352__RESET_B net11 VGND VGND VPWR VPWR sky130_fd_sc_hd__diode_2
XFILLER_0_14_100 VGND VGND VPWR VPWR sky130_fd_sc_hd__fill_1
XFILLER_0_6_377 VGND VGND VPWR VPWR sky130_fd_sc_hd__decap_4
X_3766_ tree_instances\[9\].u_tree.frame_id_out\[1\] tree_instances\[9\].u_tree.pipeline_frame_id\[0\]\[1\]
+ _1649_ VGND VGND VPWR VPWR _1225_ sky130_fd_sc_hd__mux2_1
XFILLER_0_14_155 VPWR VGND VPWR VGND sky130_ef_sc_hd__decap_12
XFILLER_0_14_144 VGND VGND VPWR VPWR sky130_fd_sc_hd__decap_8
X_2717_ _2032_ VGND VGND VPWR VPWR _2033_ sky130_fd_sc_hd__clkbuf_1
X_3697_ _1185_ VGND VGND VPWR VPWR _0299_ sky130_fd_sc_hd__clkbuf_1
XFILLER_0_72_3 VPWR VGND VPWR VGND sky130_ef_sc_hd__decap_12
X_2648_ _1793_ tree_instances\[16\].u_tree.tree_state\[2\] VGND VGND VPWR VPWR _1971_
+ sky130_fd_sc_hd__and2b_1
X_2579_ tree_instances\[1\].u_tree.pipeline_current_node\[0\]\[4\] VGND VGND VPWR
+ VPWR _1912_ sky130_fd_sc_hd__clkbuf_1
XFILLER_0_10_383 VPWR VGND VPWR VGND sky130_ef_sc_hd__decap_12
X_4318_ tree_instances\[20\].u_tree.frame_id_out\[3\] tree_instances\[20\].u_tree.pipeline_frame_id\[0\]\[3\]
+ _1908_ VGND VGND VPWR VPWR _1542_ sky130_fd_sc_hd__mux2_1
X_4249_ _1984_ _1502_ VGND VGND VPWR VPWR _1507_ sky130_fd_sc_hd__and2_1
XTAP_TAPCELL_ROW_2_232 VGND VPWR sky130_fd_sc_hd__tapvpwrvgnd_1
XFILLER_0_96_125 VPWR VGND VPWR VGND sky130_ef_sc_hd__decap_12
XFILLER_0_96_169 VPWR VGND VPWR VGND sky130_ef_sc_hd__decap_12
XFILLER_0_84_309 VPWR VGND VPWR VGND sky130_ef_sc_hd__decap_12
XFILLER_0_37_225 VGND VGND VPWR VPWR sky130_fd_sc_hd__fill_2
XFILLER_0_37_236 VGND VGND VPWR VPWR sky130_fd_sc_hd__fill_2
XFILLER_0_52_206 VGND VGND VPWR VPWR sky130_fd_sc_hd__fill_2
XFILLER_0_52_239 VGND VGND VPWR VPWR sky130_fd_sc_hd__decap_6
XPHY_EDGE_ROW_2_Left_99 VGND VGND VPWR VPWR sky130_fd_sc_hd__decap_3
XFILLER_0_87_136 VGND VGND VPWR VPWR sky130_fd_sc_hd__fill_1
XFILLER_0_87_147 VPWR VGND VPWR VGND sky130_ef_sc_hd__decap_12
XTAP_TAPCELL_ROW_72_930 VGND VPWR sky130_fd_sc_hd__tapvpwrvgnd_1
XANTENNA__4863__RESET_B net10 VGND VGND VPWR VPWR sky130_fd_sc_hd__diode_2
XFILLER_0_68_361 VGND VGND VPWR VPWR sky130_fd_sc_hd__fill_1
XFILLER_0_28_203 VGND VGND VPWR VPWR sky130_fd_sc_hd__fill_1
XFILLER_0_56_523 VGND VGND VPWR VPWR sky130_fd_sc_hd__decap_3
XFILLER_0_83_320 VGND VGND VPWR VPWR sky130_fd_sc_hd__fill_2
XFILLER_0_7_119 VGND VGND VPWR VPWR sky130_fd_sc_hd__fill_1
XTAP_TAPCELL_ROW_16_367 VGND VPWR sky130_fd_sc_hd__tapvpwrvgnd_1
XFILLER_0_71_526 VPWR VGND VPWR VGND sky130_ef_sc_hd__decap_12
XFILLER_0_43_206 VGND VGND VPWR VPWR sky130_fd_sc_hd__fill_2
XFILLER_0_83_397 VPWR VGND VPWR VGND sky130_ef_sc_hd__decap_12
X_3620_ tree_instances\[0\].u_tree.pipeline_valid\[0\] tree_instances\[0\].u_tree.tree_state\[0\]
+ VGND VGND VPWR VPWR _1135_ sky130_fd_sc_hd__nand2_1
XFILLER_0_36_280 VPWR VGND VPWR VGND sky130_ef_sc_hd__decap_12
X_3551_ _1772_ VGND VGND VPWR VPWR _1089_ sky130_fd_sc_hd__inv_2
X_2502_ tree_instances\[3\].u_tree.pipeline_current_node\[0\]\[3\] VGND VGND VPWR
+ VPWR _1848_ sky130_fd_sc_hd__clkbuf_1
XFILLER_0_24_475 VGND VGND VPWR VPWR sky130_fd_sc_hd__fill_1
XFILLER_0_51_261 VPWR VGND VPWR VGND sky130_ef_sc_hd__decap_12
XFILLER_0_11_125 VGND VGND VPWR VPWR sky130_fd_sc_hd__fill_2
X_3482_ tree_instances\[4\].u_tree.frame_id_out\[1\] tree_instances\[4\].u_tree.pipeline_frame_id\[0\]\[1\]
+ _1834_ VGND VGND VPWR VPWR _1045_ sky130_fd_sc_hd__mux2_1
XANTENNA__3127__A1 _0658_ VGND VGND VPWR VPWR sky130_fd_sc_hd__diode_2
XFILLER_0_11_169 VPWR VGND VPWR VGND sky130_ef_sc_hd__decap_12
X_2433_ _1786_ VGND VGND VPWR VPWR _1787_ sky130_fd_sc_hd__clkbuf_1
X_2364_ tree_instances\[13\].u_tree.pipeline_current_node\[0\]\[5\] tree_instances\[13\].u_tree.pipeline_current_node\[0\]\[4\]
+ VGND VGND VPWR VPWR _1727_ sky130_fd_sc_hd__or2_1
XPHY_EDGE_ROW_16_Left_113 VGND VGND VPWR VPWR sky130_fd_sc_hd__decap_3
X_4103_ _1414_ VGND VGND VPWR VPWR _0476_ sky130_fd_sc_hd__clkbuf_1
X_2295_ tree_instances\[8\].u_tree.tree_state\[2\] _1665_ tree_instances\[8\].u_tree.tree_state\[1\]
+ VGND VGND VPWR VPWR _0080_ sky130_fd_sc_hd__a21o_1
XFILLER_0_47_96 VGND VGND VPWR VPWR sky130_fd_sc_hd__decap_8
X_4034_ _1327_ _1376_ VGND VGND VPWR VPWR _1379_ sky130_fd_sc_hd__and2_1
XFILLER_0_59_361 VPWR VGND VPWR VGND sky130_ef_sc_hd__decap_12
XFILLER_0_47_501 VGND VGND VPWR VPWR sky130_fd_sc_hd__decap_3
XFILLER_0_86_180 VGND VGND VPWR VPWR sky130_fd_sc_hd__fill_2
XANTENNA__4533__RESET_B net11 VGND VGND VPWR VPWR sky130_fd_sc_hd__diode_2
X_4867_ clknet_leaf_33_clk _0021_ net10 VGND VGND VPWR VPWR tree_instances\[19\].u_tree.tree_state\[1\]
+ sky130_fd_sc_hd__dfrtp_1
XPHY_EDGE_ROW_25_Left_122 VGND VGND VPWR VPWR sky130_fd_sc_hd__decap_3
XFILLER_0_34_206 VGND VGND VPWR VPWR sky130_fd_sc_hd__fill_2
XFILLER_0_6_141 VGND VGND VPWR VPWR sky130_fd_sc_hd__decap_4
XFILLER_0_15_420 VGND VGND VPWR VPWR sky130_fd_sc_hd__decap_3
X_3818_ _1597_ _1090_ _0618_ tree_instances\[10\].u_tree.ready_for_next VGND VGND
+ VPWR VPWR _0354_ sky130_fd_sc_hd__a22o_1
X_4798_ clknet_leaf_53_clk _0485_ net13 VGND VGND VPWR VPWR tree_instances\[17\].u_tree.pipeline_current_node\[0\]\[2\]
+ sky130_fd_sc_hd__dfrtp_1
XFILLER_0_6_174 VGND VGND VPWR VPWR sky130_fd_sc_hd__fill_2
X_3749_ _1216_ VGND VGND VPWR VPWR _0320_ sky130_fd_sc_hd__clkbuf_1
XFILLER_0_88_70 VGND VGND VPWR VPWR sky130_fd_sc_hd__decap_4
XANTENNA_clkbuf_leaf_63_clk_A clknet_3_1__leaf_clk VGND VGND VPWR VPWR sky130_fd_sc_hd__diode_2
XANTENNA__3118__A1 _0714_ VGND VGND VPWR VPWR sky130_fd_sc_hd__diode_2
XANTENNA__3118__B2 _0697_ VGND VGND VPWR VPWR sky130_fd_sc_hd__diode_2
XPHY_EDGE_ROW_34_Left_131 VGND VGND VPWR VPWR sky130_fd_sc_hd__decap_3
XFILLER_0_69_125 VGND VGND VPWR VPWR sky130_fd_sc_hd__fill_2
XTAP_TAPCELL_ROW_83_1037 VGND VPWR sky130_fd_sc_hd__tapvpwrvgnd_1
XPHY_EDGE_ROW_43_Left_140 VGND VGND VPWR VPWR sky130_fd_sc_hd__decap_3
XFILLER_0_84_139 VGND VGND VPWR VPWR sky130_fd_sc_hd__fill_1
XANTENNA_clkbuf_leaf_16_clk_A clknet_3_2__leaf_clk VGND VGND VPWR VPWR sky130_fd_sc_hd__diode_2
XFILLER_0_65_353 VGND VGND VPWR VPWR sky130_fd_sc_hd__decap_8
XTAP_TAPCELL_ROW_13_337 VGND VPWR sky130_fd_sc_hd__tapvpwrvgnd_1
XFILLER_0_25_206 VGND VGND VPWR VPWR sky130_fd_sc_hd__fill_2
XFILLER_0_65_397 VGND VGND VPWR VPWR sky130_fd_sc_hd__fill_1
XFILLER_0_53_537 VGND VGND VPWR VPWR sky130_fd_sc_hd__fill_1
XFILLER_0_33_272 VGND VGND VPWR VPWR sky130_fd_sc_hd__decap_8
XTAP_TAPCELL_ROW_94_1144 VGND VPWR sky130_fd_sc_hd__tapvpwrvgnd_1
XANTENNA__3109__A1 _0654_ VGND VGND VPWR VPWR sky130_fd_sc_hd__diode_2
XFILLER_0_68_29 VGND VGND VPWR VPWR sky130_fd_sc_hd__fill_2
XTAP_TAPCELL_ROW_49_702 VGND VPWR sky130_fd_sc_hd__tapvpwrvgnd_1
XFILLER_0_17_55 VGND VGND VPWR VPWR sky130_fd_sc_hd__fill_1
XANTENNA__3293__B1 _0018_ VGND VGND VPWR VPWR sky130_fd_sc_hd__diode_2
XFILLER_0_88_445 VPWR VGND VPWR VGND sky130_ef_sc_hd__decap_12
XFILLER_0_48_309 VGND VGND VPWR VPWR sky130_fd_sc_hd__decap_6
XFILLER_0_8_406 VPWR VGND VPWR VGND sky130_ef_sc_hd__decap_12
XFILLER_0_29_545 VPWR VGND VPWR VGND sky130_ef_sc_hd__decap_12
X_2982_ current_voting_frame\[4\] VGND VGND VPWR VPWR _0660_ sky130_fd_sc_hd__buf_2
XFILLER_0_16_206 VGND VGND VPWR VPWR sky130_fd_sc_hd__decap_6
X_4721_ clknet_leaf_63_clk _0419_ tree_instances\[0\].u_tree.rst_n VGND VGND VPWR
+ VPWR tree_instances\[4\].u_tree.pipeline_valid\[0\] sky130_fd_sc_hd__dfrtp_1
XFILLER_0_83_194 VGND VGND VPWR VPWR sky130_fd_sc_hd__fill_2
XFILLER_0_83_183 VGND VGND VPWR VPWR sky130_fd_sc_hd__fill_2
X_4652_ clknet_leaf_12_clk _0357_ tree_instances\[0\].u_tree.rst_n VGND VGND VPWR
+ VPWR tree_instances\[11\].u_tree.pipeline_current_node\[0\]\[0\] sky130_fd_sc_hd__dfrtp_1
X_3603_ _1126_ VGND VGND VPWR VPWR _0264_ sky130_fd_sc_hd__clkbuf_1
X_4583_ clknet_leaf_24_clk _0303_ net11 VGND VGND VPWR VPWR tree_instances\[8\].u_tree.pipeline_frame_id\[0\]\[0\]
+ sky130_fd_sc_hd__dfrtp_1
XFILLER_0_24_250 VGND VGND VPWR VPWR sky130_fd_sc_hd__fill_2
X_3534_ _1080_ VGND VGND VPWR VPWR _0241_ sky130_fd_sc_hd__clkbuf_1
X_3465_ _1036_ VGND VGND VPWR VPWR _0216_ sky130_fd_sc_hd__clkbuf_1
X_2416_ _1575_ tree_instances\[5\].u_tree.pipeline_valid\[0\] VGND VGND VPWR VPWR
+ _1771_ sky130_fd_sc_hd__or2_1
XFILLER_0_58_95 VPWR VGND VPWR VGND sky130_ef_sc_hd__decap_12
X_3396_ tree_instances\[3\].u_tree.tree_state\[2\] tree_instances\[3\].u_tree.tree_state\[1\]
+ _0630_ VGND VGND VPWR VPWR _0995_ sky130_fd_sc_hd__or3_1
X_2347_ _1707_ _1709_ _1710_ VGND VGND VPWR VPWR _1711_ sky130_fd_sc_hd__or3b_1
XFILLER_0_35_3 VGND VGND VPWR VPWR sky130_fd_sc_hd__decap_4
X_2278_ tree_instances\[9\].u_tree.tree_state\[0\] _1648_ _1649_ VGND VGND VPWR VPWR
+ _0081_ sky130_fd_sc_hd__a21o_1
XFILLER_0_79_434 VGND VGND VPWR VPWR sky130_fd_sc_hd__fill_1
XFILLER_0_74_83 VGND VGND VPWR VPWR sky130_fd_sc_hd__fill_1
X_4017_ tree_instances\[14\].u_tree.frame_id_out\[1\] tree_instances\[14\].u_tree.pipeline_frame_id\[0\]\[1\]
+ _1889_ VGND VGND VPWR VPWR _1370_ sky130_fd_sc_hd__mux2_1
XANTENNA__4785__RESET_B net13 VGND VGND VPWR VPWR sky130_fd_sc_hd__diode_2
XANTENNA__4714__RESET_B net9 VGND VGND VPWR VPWR sky130_fd_sc_hd__diode_2
XFILLER_0_90_82 VGND VGND VPWR VPWR sky130_fd_sc_hd__fill_2
XFILLER_0_66_139 VGND VGND VPWR VPWR sky130_fd_sc_hd__fill_1
XFILLER_0_62_301 VGND VGND VPWR VPWR sky130_fd_sc_hd__decap_6
XTAP_TAPCELL_ROW_10_307 VGND VPWR sky130_fd_sc_hd__tapvpwrvgnd_1
XFILLER_0_7_461 VPWR VGND VPWR VGND sky130_ef_sc_hd__decap_12
XFILLER_0_50_529 VGND VGND VPWR VPWR sky130_fd_sc_hd__decap_3
XFILLER_0_30_253 VGND VGND VPWR VPWR sky130_fd_sc_hd__decap_4
XANTENNA__4455__RESET_B net9 VGND VGND VPWR VPWR sky130_fd_sc_hd__diode_2
XFILLER_0_85_404 VPWR VGND VPWR VGND sky130_ef_sc_hd__decap_12
XFILLER_0_85_437 VGND VGND VPWR VPWR sky130_fd_sc_hd__fill_2
XFILLER_0_70_19 VGND VGND VPWR VPWR sky130_fd_sc_hd__fill_1
XTAP_TAPCELL_ROW_26_473 VGND VPWR sky130_fd_sc_hd__tapvpwrvgnd_1
XFILLER_0_38_331 VGND VGND VPWR VPWR sky130_fd_sc_hd__decap_4
XFILLER_0_65_150 VGND VGND VPWR VPWR sky130_fd_sc_hd__fill_2
XFILLER_0_38_342 VGND VGND VPWR VPWR sky130_fd_sc_hd__decap_8
XFILLER_0_65_194 VPWR VGND VPWR VGND sky130_ef_sc_hd__decap_12
XFILLER_0_26_559 VPWR VGND VPWR VGND sky130_ef_sc_hd__decap_12
XFILLER_0_80_175 VGND VGND VPWR VPWR sky130_fd_sc_hd__decap_6
XFILLER_0_80_197 VGND VGND VPWR VPWR sky130_fd_sc_hd__decap_8
XFILLER_0_0_125 VPWR VGND VPWR VGND sky130_ef_sc_hd__decap_12
XFILLER_0_21_242 VGND VGND VPWR VPWR sky130_fd_sc_hd__decap_6
XFILLER_0_95_27 VPWR VGND VPWR VGND sky130_ef_sc_hd__decap_12
XFILLER_0_0_169 VPWR VGND VPWR VGND sky130_ef_sc_hd__decap_12
X_3250_ _0911_ VGND VGND VPWR VPWR _0912_ sky130_fd_sc_hd__dlymetal6s2s_1
XFILLER_0_28_21 VGND VGND VPWR VPWR sky130_fd_sc_hd__decap_6
XFILLER_0_28_32 VGND VGND VPWR VPWR sky130_fd_sc_hd__fill_2
X_3181_ tree_instances\[8\].u_tree.frame_id_out\[4\] VGND VGND VPWR VPWR _0853_ sky130_fd_sc_hd__inv_2
X_2201_ _1580_ VGND VGND VPWR VPWR _1581_ sky130_fd_sc_hd__clkbuf_1
XFILLER_0_88_231 VGND VGND VPWR VPWR sky130_fd_sc_hd__fill_1
XFILLER_0_44_53 VGND VGND VPWR VPWR sky130_fd_sc_hd__decap_6
XFILLER_0_88_253 VGND VGND VPWR VPWR sky130_fd_sc_hd__decap_3
XFILLER_0_29_331 VGND VGND VPWR VPWR sky130_fd_sc_hd__decap_4
XFILLER_0_63_109 VGND VGND VPWR VPWR sky130_fd_sc_hd__decap_3
XFILLER_0_8_225 VGND VGND VPWR VPWR sky130_fd_sc_hd__fill_2
X_2965_ _0646_ VGND VGND VPWR VPWR _0647_ sky130_fd_sc_hd__clkbuf_4
X_4704_ clknet_leaf_0_clk _0407_ net9 VGND VGND VPWR VPWR tree_instances\[13\].u_tree.pipeline_current_node\[0\]\[8\]
+ sky130_fd_sc_hd__dfrtp_1
XFILLER_0_29_397 VGND VGND VPWR VPWR sky130_fd_sc_hd__decap_8
XFILLER_0_17_559 VGND VGND VPWR VPWR sky130_fd_sc_hd__fill_1
X_2896_ _0601_ _1576_ VGND VGND VPWR VPWR _0602_ sky130_fd_sc_hd__or2_1
XFILLER_0_44_389 VGND VGND VPWR VPWR sky130_fd_sc_hd__decap_6
X_4635_ clknet_leaf_11_clk _0345_ tree_instances\[0\].u_tree.rst_n VGND VGND VPWR
+ VPWR tree_instances\[10\].u_tree.pipeline_frame_id\[0\]\[1\] sky130_fd_sc_hd__dfrtp_1
XFILLER_0_4_475 VGND VGND VPWR VPWR sky130_fd_sc_hd__fill_1
X_4566_ clknet_leaf_5_clk _0287_ net9 VGND VGND VPWR VPWR tree_instances\[7\].u_tree.pipeline_frame_id\[0\]\[4\]
+ sky130_fd_sc_hd__dfrtp_1
XFILLER_0_69_72 VGND VGND VPWR VPWR sky130_fd_sc_hd__decap_4
X_3517_ _1069_ _1054_ VGND VGND VPWR VPWR _1070_ sky130_fd_sc_hd__and2_1
X_4497_ clknet_leaf_3_clk _0003_ tree_instances\[0\].u_tree.rst_n VGND VGND VPWR VPWR
+ tree_instances\[10\].u_tree.tree_state\[1\] sky130_fd_sc_hd__dfrtp_1
X_3448_ tree_instances\[13\].u_tree.tree_state\[0\] _1576_ VGND VGND VPWR VPWR _1027_
+ sky130_fd_sc_hd__nand2_1
X_3379_ _0986_ VGND VGND VPWR VPWR _0180_ sky130_fd_sc_hd__clkbuf_1
XTAP_TAPCELL_ROW_68_885 VGND VPWR sky130_fd_sc_hd__tapvpwrvgnd_1
XFILLER_0_94_234 VGND VGND VPWR VPWR sky130_fd_sc_hd__fill_2
XTAP_TAPCELL_ROW_80_1007 VGND VPWR sky130_fd_sc_hd__tapvpwrvgnd_1
XFILLER_0_82_418 VGND VGND VPWR VPWR sky130_fd_sc_hd__fill_2
XFILLER_0_54_109 VGND VGND VPWR VPWR sky130_fd_sc_hd__decap_3
XFILLER_0_82_429 VGND VGND VPWR VPWR sky130_fd_sc_hd__fill_1
XTAP_TAPCELL_ROW_23_443 VGND VPWR sky130_fd_sc_hd__tapvpwrvgnd_1
XFILLER_0_23_529 VPWR VGND VPWR VGND sky130_ef_sc_hd__decap_12
XFILLER_0_35_367 VGND VGND VPWR VPWR sky130_fd_sc_hd__fill_1
XFILLER_0_90_495 VPWR VGND VPWR VGND sky130_ef_sc_hd__decap_12
XFILLER_0_62_197 VGND VGND VPWR VPWR sky130_fd_sc_hd__decap_8
XFILLER_0_62_186 VGND VGND VPWR VPWR sky130_fd_sc_hd__fill_1
XTAP_TAPCELL_ROW_91_1114 VGND VPWR sky130_fd_sc_hd__tapvpwrvgnd_1
XANTENNA__4636__RESET_B tree_instances\[0\].u_tree.rst_n VGND VGND VPWR VPWR sky130_fd_sc_hd__diode_2
XTAP_TAPCELL_ROW_89_1098 VGND VPWR sky130_fd_sc_hd__tapvpwrvgnd_1
XFILLER_0_85_201 VGND VGND VPWR VPWR sky130_fd_sc_hd__fill_2
XFILLER_0_58_437 VPWR VGND VPWR VGND sky130_ef_sc_hd__decap_12
XFILLER_0_14_45 VGND VGND VPWR VPWR sky130_fd_sc_hd__fill_1
XFILLER_0_85_278 VGND VGND VPWR VPWR sky130_fd_sc_hd__fill_2
XFILLER_0_85_289 VGND VGND VPWR VPWR sky130_fd_sc_hd__fill_2
X_2750_ _2053_ VGND VGND VPWR VPWR _2061_ sky130_fd_sc_hd__clkbuf_1
XFILLER_0_81_473 VGND VGND VPWR VPWR sky130_fd_sc_hd__decap_3
X_2681_ _2001_ VGND VGND VPWR VPWR _2002_ sky130_fd_sc_hd__clkbuf_1
XFILLER_0_26_389 VGND VGND VPWR VPWR sky130_fd_sc_hd__decap_3
XFILLER_0_53_164 VGND VGND VPWR VPWR sky130_fd_sc_hd__fill_2
X_4420_ clknet_leaf_22_clk _0096_ net11 VGND VGND VPWR VPWR tree_instances\[1\].u_tree.prediction_valid
+ sky130_fd_sc_hd__dfrtp_1
XFILLER_0_30_66 VGND VGND VPWR VPWR sky130_fd_sc_hd__fill_2
XFILLER_0_41_337 VGND VGND VPWR VPWR sky130_fd_sc_hd__decap_8
XFILLER_0_53_197 VPWR VGND VPWR VGND sky130_ef_sc_hd__decap_12
XFILLER_0_22_562 VPWR VGND VPWR VGND sky130_ef_sc_hd__decap_12
X_4351_ clknet_leaf_27_clk _0111_ net11 VGND VGND VPWR VPWR tree_instances\[0\].u_tree.frame_id_in\[0\]
+ sky130_fd_sc_hd__dfrtp_1
XFILLER_0_1_445 VGND VGND VPWR VPWR sky130_fd_sc_hd__decap_3
X_3302_ _0573_ _0936_ VGND VGND VPWR VPWR _0940_ sky130_fd_sc_hd__and2_1
X_4282_ tree_instances\[20\].u_tree.tree_state\[1\] tree_instances\[20\].u_tree.tree_state\[2\]
+ _0634_ VGND VGND VPWR VPWR _1523_ sky130_fd_sc_hd__or3_1
XFILLER_0_39_53 VGND VGND VPWR VPWR sky130_fd_sc_hd__decap_3
XANTENNA_clkbuf_3_3__f_clk_A clknet_0_clk VGND VGND VPWR VPWR sky130_fd_sc_hd__diode_2
X_3233_ _0721_ _0765_ _0884_ _0896_ _0897_ VGND VGND VPWR VPWR _0902_ sky130_fd_sc_hd__a32o_1
XANTENNA__4377__RESET_B net13 VGND VGND VPWR VPWR sky130_fd_sc_hd__diode_2
X_3164_ _0726_ tree_instances\[11\].u_tree.frame_id_out\[0\] VGND VGND VPWR VPWR _0836_
+ sky130_fd_sc_hd__xnor2_1
X_3095_ _0690_ tree_instances\[1\].u_tree.frame_id_out\[3\] tree_instances\[1\].u_tree.frame_id_out\[0\]
+ _0647_ VGND VGND VPWR VPWR _0767_ sky130_fd_sc_hd__o2bb2a_1
XFILLER_0_89_573 VGND VGND VPWR VPWR sky130_fd_sc_hd__fill_1
XTAP_TAPCELL_ROW_65_855 VGND VPWR sky130_fd_sc_hd__tapvpwrvgnd_1
XTAP_TAPCELL_ROW_37_579 VGND VPWR sky130_fd_sc_hd__tapvpwrvgnd_1
XFILLER_0_71_62 VGND VGND VPWR VPWR sky130_fd_sc_hd__fill_2
XFILLER_0_91_237 VPWR VGND VPWR VGND sky130_ef_sc_hd__decap_12
X_3997_ _1289_ _1354_ VGND VGND VPWR VPWR _1360_ sky130_fd_sc_hd__and2_1
XANTENNA__2780__B _1889_ VGND VGND VPWR VPWR sky130_fd_sc_hd__diode_2
XFILLER_0_29_161 VGND VGND VPWR VPWR sky130_fd_sc_hd__decap_6
X_2948_ tree_instances\[14\].u_tree.tree_state\[0\] VGND VGND VPWR VPWR _0635_ sky130_fd_sc_hd__inv_2
XFILLER_0_17_334 VGND VGND VPWR VPWR sky130_fd_sc_hd__fill_2
XTAP_TAPCELL_ROW_20_413 VGND VPWR sky130_fd_sc_hd__tapvpwrvgnd_1
XFILLER_0_72_473 VGND VGND VPWR VPWR sky130_fd_sc_hd__decap_3
XANTENNA__3962__A1 _1162_ VGND VGND VPWR VPWR sky130_fd_sc_hd__diode_2
X_4618_ clknet_leaf_10_clk _0333_ net12 VGND VGND VPWR VPWR tree_instances\[9\].u_tree.ready_for_next
+ sky130_fd_sc_hd__dfstp_1
X_2879_ _0585_ VGND VGND VPWR VPWR _0586_ sky130_fd_sc_hd__clkbuf_1
XFILLER_0_32_348 VGND VGND VPWR VPWR sky130_fd_sc_hd__decap_4
XFILLER_0_13_573 VGND VGND VPWR VPWR sky130_fd_sc_hd__fill_1
X_4549_ clknet_leaf_47_clk _0058_ net10 VGND VGND VPWR VPWR tree_instances\[17\].u_tree.tree_state\[0\]
+ sky130_fd_sc_hd__dfstp_1
XFILLER_0_40_381 VGND VGND VPWR VPWR sky130_fd_sc_hd__fill_2
XPHY_EDGE_ROW_8_Left_105 VGND VGND VPWR VPWR sky130_fd_sc_hd__decap_3
XFILLER_0_96_81 VGND VGND VPWR VPWR sky130_fd_sc_hd__decap_3
XFILLER_0_35_131 VGND VGND VPWR VPWR sky130_fd_sc_hd__fill_2
XFILLER_0_63_473 VGND VGND VPWR VPWR sky130_fd_sc_hd__decap_8
Xclkload19 clknet_leaf_66_clk VGND VGND VPWR VPWR clkload19/Y sky130_fd_sc_hd__inv_6
XFILLER_0_23_337 VGND VGND VPWR VPWR sky130_fd_sc_hd__decap_6
XFILLER_0_50_178 VGND VGND VPWR VPWR sky130_fd_sc_hd__fill_2
XANTENNA__4888__RESET_B net10 VGND VGND VPWR VPWR sky130_fd_sc_hd__diode_2
XFILLER_0_76_29 VGND VGND VPWR VPWR sky130_fd_sc_hd__fill_1
XTAP_TAPCELL_ROW_8_293 VGND VPWR sky130_fd_sc_hd__tapvpwrvgnd_1
XANTENNA__4470__RESET_B net9 VGND VGND VPWR VPWR sky130_fd_sc_hd__diode_2
X_3920_ _1312_ VGND VGND VPWR VPWR _0395_ sky130_fd_sc_hd__clkbuf_1
XTAP_TAPCELL_ROW_62_825 VGND VPWR sky130_fd_sc_hd__tapvpwrvgnd_1
XFILLER_0_58_234 VPWR VGND VPWR VGND sky130_ef_sc_hd__decap_12
XTAP_TAPCELL_ROW_34_549 VGND VPWR sky130_fd_sc_hd__tapvpwrvgnd_1
XFILLER_0_58_289 VPWR VGND VPWR VGND sky130_ef_sc_hd__decap_12
XFILLER_0_41_21 VGND VGND VPWR VPWR sky130_fd_sc_hd__fill_1
XFILLER_0_46_418 VGND VGND VPWR VPWR sky130_fd_sc_hd__fill_2
X_3851_ _1269_ VGND VGND VPWR VPWR _0369_ sky130_fd_sc_hd__clkbuf_1
X_3782_ _0580_ _1232_ VGND VGND VPWR VPWR _1234_ sky130_fd_sc_hd__and2_1
X_2802_ _2106_ VGND VGND VPWR VPWR _0093_ sky130_fd_sc_hd__clkbuf_1
XFILLER_0_41_54 VGND VGND VPWR VPWR sky130_fd_sc_hd__fill_2
XFILLER_0_41_87 VGND VGND VPWR VPWR sky130_fd_sc_hd__decap_6
X_2733_ _2045_ VGND VGND VPWR VPWR _0105_ sky130_fd_sc_hd__clkbuf_1
XFILLER_0_54_462 VGND VGND VPWR VPWR sky130_fd_sc_hd__decap_3
XFILLER_0_81_281 VGND VGND VPWR VPWR sky130_fd_sc_hd__decap_4
X_2664_ _1979_ VGND VGND VPWR VPWR _1986_ sky130_fd_sc_hd__clkbuf_1
XFILLER_0_41_167 VGND VGND VPWR VPWR sky130_fd_sc_hd__fill_1
X_4403_ clknet_leaf_21_clk _0150_ net11 VGND VGND VPWR VPWR tree_instances\[1\].u_tree.pipeline_current_node\[0\]\[3\]
+ sky130_fd_sc_hd__dfrtp_1
X_2595_ _1893_ VGND VGND VPWR VPWR _1927_ sky130_fd_sc_hd__clkbuf_1
X_4334_ clknet_leaf_17_clk _0007_ net11 VGND VGND VPWR VPWR tree_instances\[12\].u_tree.tree_state\[1\]
+ sky130_fd_sc_hd__dfrtp_1
XFILLER_0_1_264 VGND VGND VPWR VPWR sky130_fd_sc_hd__decap_8
XANTENNA__4558__RESET_B tree_instances\[0\].u_tree.rst_n VGND VGND VPWR VPWR sky130_fd_sc_hd__diode_2
X_4265_ tree_instances\[19\].u_tree.pipeline_frame_id\[0\]\[3\] _0678_ _0022_ VGND
+ VGND VPWR VPWR _1515_ sky130_fd_sc_hd__mux2_1
X_3216_ complete_votes\[1\] VGND VGND VPWR VPWR _0887_ sky130_fd_sc_hd__inv_2
XFILLER_0_5_98 VGND VGND VPWR VPWR sky130_fd_sc_hd__fill_2
X_4196_ _1479_ VGND VGND VPWR VPWR _0504_ sky130_fd_sc_hd__clkbuf_1
XTAP_TAPCELL_ROW_78_991 VGND VPWR sky130_fd_sc_hd__tapvpwrvgnd_1
X_3147_ _0648_ tree_instances\[12\].u_tree.frame_id_out\[0\] tree_instances\[12\].u_tree.frame_id_out\[2\]
+ _0714_ VGND VGND VPWR VPWR _0819_ sky130_fd_sc_hd__o2bb2a_1
X_3078_ _0660_ tree_instances\[19\].u_tree.frame_id_out\[4\] VGND VGND VPWR VPWR _0750_
+ sky130_fd_sc_hd__xnor2_1
XFILLER_0_92_557 VPWR VGND VPWR VGND sky130_ef_sc_hd__decap_12
XFILLER_0_45_473 VPWR VGND VPWR VGND sky130_ef_sc_hd__decap_12
XFILLER_0_72_270 VGND VGND VPWR VPWR sky130_fd_sc_hd__fill_2
XFILLER_0_17_175 VGND VGND VPWR VPWR sky130_fd_sc_hd__fill_2
XFILLER_0_60_454 VGND VGND VPWR VPWR sky130_fd_sc_hd__fill_2
XFILLER_0_32_145 VGND VGND VPWR VPWR sky130_fd_sc_hd__decap_8
XANTENNA__2966__A _0647_ VGND VGND VPWR VPWR sky130_fd_sc_hd__diode_2
XTAP_TAPCELL_ROW_5_263 VGND VPWR sky130_fd_sc_hd__tapvpwrvgnd_1
XTAP_TAPCELL_ROW_86_1068 VGND VPWR sky130_fd_sc_hd__tapvpwrvgnd_1
XFILLER_0_68_510 VGND VGND VPWR VPWR sky130_fd_sc_hd__fill_2
XFILLER_0_95_384 VGND VGND VPWR VPWR sky130_fd_sc_hd__fill_1
XTAP_TAPCELL_ROW_31_519 VGND VPWR sky130_fd_sc_hd__tapvpwrvgnd_1
XFILLER_0_63_281 VGND VGND VPWR VPWR sky130_fd_sc_hd__decap_4
XFILLER_0_11_57 VPWR VGND VPWR VGND sky130_ef_sc_hd__decap_12
XFILLER_0_3_529 VPWR VGND VPWR VGND sky130_ef_sc_hd__decap_12
XANTENNA__4651__RESET_B net12 VGND VGND VPWR VPWR sky130_fd_sc_hd__diode_2
X_2380_ tree_instances\[14\].u_tree.pipeline_current_node\[0\]\[1\] VGND VGND VPWR
+ VPWR _1741_ sky130_fd_sc_hd__clkbuf_1
X_4050_ tree_instances\[15\].u_tree.pipeline_frame_id\[0\]\[1\] _0672_ _0014_ VGND
+ VGND VPWR VPWR _1387_ sky130_fd_sc_hd__mux2_1
X_3001_ _0673_ _0671_ _0675_ VGND VGND VPWR VPWR _0676_ sky130_fd_sc_hd__a21oi_1
XFILLER_0_78_318 VGND VGND VPWR VPWR sky130_fd_sc_hd__fill_2
XTAP_TAPCELL_ROW_75_961 VGND VPWR sky130_fd_sc_hd__tapvpwrvgnd_1
XTAP_TAPCELL_ROW_47_674 VGND VPWR sky130_fd_sc_hd__tapvpwrvgnd_1
XTAP_TAPCELL_ROW_19_398 VGND VPWR sky130_fd_sc_hd__tapvpwrvgnd_1
X_3903_ tree_instances\[12\].u_tree.pipeline_frame_id\[0\]\[0\] _1162_ _0008_ VGND
+ VGND VPWR VPWR _1304_ sky130_fd_sc_hd__mux2_1
X_4883_ clknet_leaf_40_clk _0555_ net10 VGND VGND VPWR VPWR tree_instances\[20\].u_tree.pipeline_current_node\[0\]\[8\]
+ sky130_fd_sc_hd__dfrtp_1
XFILLER_0_19_429 VGND VGND VPWR VPWR sky130_fd_sc_hd__decap_6
XANTENNA__3090__A1 _0685_ VGND VGND VPWR VPWR sky130_fd_sc_hd__diode_2
XANTENNA__2968__A2 _0645_ VGND VGND VPWR VPWR sky130_fd_sc_hd__diode_2
X_3834_ _1260_ _1255_ VGND VGND VPWR VPWR _1261_ sky130_fd_sc_hd__and2_1
XFILLER_0_6_312 VPWR VGND VPWR VGND sky130_ef_sc_hd__decap_12
XFILLER_0_61_229 VPWR VGND VPWR VGND sky130_ef_sc_hd__decap_12
XFILLER_0_6_356 VGND VGND VPWR VPWR sky130_fd_sc_hd__fill_2
XFILLER_0_27_473 VPWR VGND VPWR VGND sky130_ef_sc_hd__decap_12
X_3765_ _1224_ VGND VGND VPWR VPWR _0328_ sky130_fd_sc_hd__clkbuf_1
X_3696_ _2083_ _1179_ VGND VGND VPWR VPWR _1185_ sky130_fd_sc_hd__and2_1
XANTENNA__4739__RESET_B net11 VGND VGND VPWR VPWR sky130_fd_sc_hd__diode_2
XFILLER_0_54_292 VGND VGND VPWR VPWR sky130_fd_sc_hd__fill_2
X_2716_ _2029_ VGND VGND VPWR VPWR _2032_ sky130_fd_sc_hd__clkbuf_1
X_2647_ tree_instances\[19\].u_tree.tree_state\[0\] _1969_ _1970_ VGND VGND VPWR VPWR
+ _0061_ sky130_fd_sc_hd__a21o_1
XFILLER_0_14_167 VGND VGND VPWR VPWR sky130_fd_sc_hd__decap_3
XANTENNA__4392__RESET_B net13 VGND VGND VPWR VPWR sky130_fd_sc_hd__diode_2
XFILLER_0_2_573 VGND VGND VPWR VPWR sky130_fd_sc_hd__fill_1
X_2578_ tree_instances\[1\].u_tree.pipeline_current_node\[0\]\[5\] VGND VGND VPWR
+ VPWR _1911_ sky130_fd_sc_hd__clkbuf_1
XFILLER_0_10_362 VGND VGND VPWR VPWR sky130_fd_sc_hd__fill_2
X_4317_ _1541_ VGND VGND VPWR VPWR _0563_ sky130_fd_sc_hd__clkbuf_1
XFILLER_0_10_395 VGND VGND VPWR VPWR sky130_fd_sc_hd__fill_1
X_4248_ _1506_ VGND VGND VPWR VPWR _0529_ sky130_fd_sc_hd__clkbuf_1
XTAP_TAPCELL_ROW_2_233 VGND VPWR sky130_fd_sc_hd__tapvpwrvgnd_1
X_4179_ _1470_ VGND VGND VPWR VPWR _0496_ sky130_fd_sc_hd__clkbuf_1
XFILLER_0_96_137 VGND VGND VPWR VPWR sky130_fd_sc_hd__decap_3
Xclkbuf_3_3__f_clk clknet_0_clk VGND VGND VPWR VPWR clknet_3_3__leaf_clk sky130_fd_sc_hd__clkbuf_16
XPHY_EDGE_ROW_14_Right_14 VGND VGND VPWR VPWR sky130_fd_sc_hd__decap_3
XFILLER_0_33_421 VGND VGND VPWR VPWR sky130_fd_sc_hd__fill_1
XANTENNA__4409__RESET_B net11 VGND VGND VPWR VPWR sky130_fd_sc_hd__diode_2
XFILLER_0_60_251 VGND VGND VPWR VPWR sky130_fd_sc_hd__fill_1
XFILLER_0_33_487 VGND VGND VPWR VPWR sky130_fd_sc_hd__fill_1
XFILLER_0_20_159 VGND VGND VPWR VPWR sky130_fd_sc_hd__fill_1
XPHY_EDGE_ROW_23_Right_23 VGND VGND VPWR VPWR sky130_fd_sc_hd__decap_3
XFILLER_0_87_104 VGND VGND VPWR VPWR sky130_fd_sc_hd__decap_6
XFILLER_0_87_159 VGND VGND VPWR VPWR sky130_fd_sc_hd__fill_2
XTAP_TAPCELL_ROW_72_931 VGND VPWR sky130_fd_sc_hd__tapvpwrvgnd_1
XANTENNA__3072__A1 _0685_ VGND VGND VPWR VPWR sky130_fd_sc_hd__diode_2
XPHY_EDGE_ROW_32_Right_32 VGND VGND VPWR VPWR sky130_fd_sc_hd__decap_3
XTAP_TAPCELL_ROW_44_644 VGND VPWR sky130_fd_sc_hd__tapvpwrvgnd_1
XFILLER_0_95_181 VGND VGND VPWR VPWR sky130_fd_sc_hd__fill_2
XTAP_TAPCELL_ROW_16_368 VGND VPWR sky130_fd_sc_hd__tapvpwrvgnd_1
XFILLER_0_28_237 VGND VGND VPWR VPWR sky130_fd_sc_hd__decap_6
XANTENNA__3072__B2 _0697_ VGND VGND VPWR VPWR sky130_fd_sc_hd__diode_2
XFILLER_0_22_45 VGND VGND VPWR VPWR sky130_fd_sc_hd__fill_1
XFILLER_0_56_568 VGND VGND VPWR VPWR sky130_fd_sc_hd__decap_6
XFILLER_0_71_538 VGND VGND VPWR VPWR sky130_fd_sc_hd__decap_8
X_3550_ _1088_ VGND VGND VPWR VPWR _0249_ sky130_fd_sc_hd__clkbuf_1
XFILLER_0_36_292 VPWR VGND VPWR VGND sky130_ef_sc_hd__decap_12
XANTENNA__4832__RESET_B net13 VGND VGND VPWR VPWR sky130_fd_sc_hd__diode_2
X_2501_ _1846_ VGND VGND VPWR VPWR _1847_ sky130_fd_sc_hd__clkbuf_1
XFILLER_0_3_337 VGND VGND VPWR VPWR sky130_fd_sc_hd__decap_4
XFILLER_0_51_273 VGND VGND VPWR VPWR sky130_fd_sc_hd__decap_6
XFILLER_0_11_137 VGND VGND VPWR VPWR sky130_fd_sc_hd__fill_2
X_3481_ _1044_ VGND VGND VPWR VPWR _0224_ sky130_fd_sc_hd__clkbuf_1
XFILLER_0_51_295 VPWR VGND VPWR VGND sky130_ef_sc_hd__decap_12
X_2432_ _1785_ VGND VGND VPWR VPWR _1786_ sky130_fd_sc_hd__clkbuf_1
XPHY_EDGE_ROW_41_Right_41 VGND VGND VPWR VPWR sky130_fd_sc_hd__decap_3
X_2363_ _1719_ _1725_ VGND VGND VPWR VPWR _1726_ sky130_fd_sc_hd__or2_1
X_4102_ tree_instances\[16\].u_tree.frame_id_out\[0\] tree_instances\[16\].u_tree.pipeline_frame_id\[0\]\[0\]
+ _1729_ VGND VGND VPWR VPWR _1414_ sky130_fd_sc_hd__mux2_1
X_2294_ _1655_ _1658_ _1662_ _1664_ VGND VGND VPWR VPWR _1665_ sky130_fd_sc_hd__and4_1
X_4033_ _1378_ VGND VGND VPWR VPWR _0442_ sky130_fd_sc_hd__clkbuf_1
XFILLER_0_63_52 VGND VGND VPWR VPWR sky130_fd_sc_hd__fill_1
XANTENNA__4894__SET_B net10 VGND VGND VPWR VPWR sky130_fd_sc_hd__diode_2
XPHY_EDGE_ROW_50_Right_50 VGND VGND VPWR VPWR sky130_fd_sc_hd__decap_3
XFILLER_0_59_373 VPWR VGND VPWR VGND sky130_ef_sc_hd__decap_12
XANTENNA__3063__B2 _0690_ VGND VGND VPWR VPWR sky130_fd_sc_hd__diode_2
XANTENNA__3063__A1 _0733_ VGND VGND VPWR VPWR sky130_fd_sc_hd__diode_2
X_4866_ clknet_leaf_34_clk _0061_ net13 VGND VGND VPWR VPWR tree_instances\[19\].u_tree.tree_state\[0\]
+ sky130_fd_sc_hd__dfstp_1
XFILLER_0_74_365 VGND VGND VPWR VPWR sky130_fd_sc_hd__fill_1
X_4797_ clknet_leaf_54_clk _0484_ tree_instances\[0\].u_tree.rst_n VGND VGND VPWR
+ VPWR tree_instances\[17\].u_tree.pipeline_current_node\[0\]\[1\] sky130_fd_sc_hd__dfrtp_1
XFILLER_0_6_153 VGND VGND VPWR VPWR sky130_fd_sc_hd__fill_1
XFILLER_0_27_281 VGND VGND VPWR VPWR sky130_fd_sc_hd__decap_4
X_3817_ _1251_ VGND VGND VPWR VPWR _0353_ sky130_fd_sc_hd__clkbuf_1
X_3748_ _1201_ _1209_ VGND VGND VPWR VPWR _1216_ sky130_fd_sc_hd__and2_1
XFILLER_0_15_454 VGND VGND VPWR VPWR sky130_fd_sc_hd__decap_6
XANTENNA__4573__RESET_B net9 VGND VGND VPWR VPWR sky130_fd_sc_hd__diode_2
XANTENNA__4502__RESET_B tree_instances\[0\].u_tree.rst_n VGND VGND VPWR VPWR sky130_fd_sc_hd__diode_2
XFILLER_0_6_197 VGND VGND VPWR VPWR sky130_fd_sc_hd__decap_6
XFILLER_0_15_487 VPWR VGND VPWR VGND sky130_ef_sc_hd__decap_12
XFILLER_0_42_251 VGND VGND VPWR VPWR sky130_fd_sc_hd__fill_1
X_3679_ _1174_ VGND VGND VPWR VPWR _0292_ sky130_fd_sc_hd__clkbuf_1
XFILLER_0_69_137 VGND VGND VPWR VPWR sky130_fd_sc_hd__decap_3
XTAP_TAPCELL_ROW_83_1038 VGND VPWR sky130_fd_sc_hd__tapvpwrvgnd_1
XFILLER_0_38_502 VPWR VGND VPWR VGND sky130_ef_sc_hd__decap_12
XTAP_TAPCELL_ROW_41_614 VGND VPWR sky130_fd_sc_hd__tapvpwrvgnd_1
XTAP_TAPCELL_ROW_13_338 VGND VPWR sky130_fd_sc_hd__tapvpwrvgnd_1
Xclkbuf_leaf_50_clk clknet_3_5__leaf_clk VGND VGND VPWR VPWR clknet_leaf_50_clk sky130_fd_sc_hd__clkbuf_4
XFILLER_0_53_505 VPWR VGND VPWR VGND sky130_ef_sc_hd__decap_12
XFILLER_0_92_195 VGND VGND VPWR VPWR sky130_fd_sc_hd__fill_1
XFILLER_0_18_281 VGND VGND VPWR VPWR sky130_fd_sc_hd__fill_1
XTAP_TAPCELL_ROW_94_1145 VGND VPWR sky130_fd_sc_hd__tapvpwrvgnd_1
XANTENNA__4306__A1 _0674_ VGND VGND VPWR VPWR sky130_fd_sc_hd__diode_2
XFILLER_0_21_457 VGND VGND VPWR VPWR sky130_fd_sc_hd__fill_1
XFILLER_0_84_29 VPWR VGND VPWR VGND sky130_ef_sc_hd__decap_12
XTAP_TAPCELL_ROW_49_703 VGND VPWR sky130_fd_sc_hd__tapvpwrvgnd_1
XFILLER_0_88_457 VPWR VGND VPWR VGND sky130_ef_sc_hd__decap_12
XTAP_TAPCELL_ROW_57_780 VGND VPWR sky130_fd_sc_hd__tapvpwrvgnd_1
XFILLER_0_29_502 VGND VGND VPWR VPWR sky130_fd_sc_hd__fill_2
X_2981_ _0659_ VGND VGND VPWR VPWR _0109_ sky130_fd_sc_hd__clkbuf_1
XFILLER_0_8_418 VGND VGND VPWR VPWR sky130_fd_sc_hd__fill_2
XFILLER_0_33_55 VGND VGND VPWR VPWR sky130_fd_sc_hd__fill_1
XFILLER_0_33_66 VGND VGND VPWR VPWR sky130_fd_sc_hd__decap_8
X_4720_ clknet_leaf_54_clk _0068_ net13 VGND VGND VPWR VPWR tree_instances\[2\].u_tree.tree_state\[3\]
+ sky130_fd_sc_hd__dfrtp_1
XFILLER_0_29_557 VGND VGND VPWR VPWR sky130_fd_sc_hd__decap_3
XFILLER_0_44_505 VGND VGND VPWR VPWR sky130_fd_sc_hd__fill_2
Xclkbuf_leaf_41_clk clknet_3_7__leaf_clk VGND VGND VPWR VPWR clknet_leaf_41_clk sky130_fd_sc_hd__clkbuf_4
X_4651_ clknet_leaf_9_clk _0356_ net12 VGND VGND VPWR VPWR tree_instances\[8\].u_tree.pipeline_valid\[0\]
+ sky130_fd_sc_hd__dfrtp_1
XFILLER_0_44_527 VGND VGND VPWR VPWR sky130_fd_sc_hd__decap_3
X_3602_ tree_instances\[6\].u_tree.pipeline_frame_id\[0\]\[2\] _0675_ _0036_ VGND
+ VGND VPWR VPWR _1126_ sky130_fd_sc_hd__mux2_1
X_4582_ clknet_leaf_15_clk _0302_ net12 VGND VGND VPWR VPWR tree_instances\[8\].u_tree.pipeline_current_node\[0\]\[8\]
+ sky130_fd_sc_hd__dfrtp_1
XFILLER_0_3_156 VGND VGND VPWR VPWR sky130_fd_sc_hd__fill_1
X_3533_ tree_instances\[5\].u_tree.pipeline_frame_id\[0\]\[1\] _0673_ _0034_ VGND
+ VGND VPWR VPWR _1080_ sky130_fd_sc_hd__mux2_1
X_3464_ _2104_ _1029_ VGND VGND VPWR VPWR _1036_ sky130_fd_sc_hd__and2_1
X_2415_ tree_instances\[5\].u_tree.tree_state\[3\] VGND VGND VPWR VPWR _1770_ sky130_fd_sc_hd__buf_2
X_3395_ _1889_ _0994_ _0012_ tree_instances\[14\].u_tree.pipeline_valid\[0\] VGND
+ VGND VPWR VPWR _0188_ sky130_fd_sc_hd__o2bb2a_1
X_2346_ tree_instances\[6\].u_tree.pipeline_current_node\[0\]\[7\] tree_instances\[6\].u_tree.pipeline_current_node\[0\]\[8\]
+ VGND VGND VPWR VPWR _1710_ sky130_fd_sc_hd__nor2_1
X_2277_ tree_instances\[9\].u_tree.tree_state\[3\] VGND VGND VPWR VPWR _1649_ sky130_fd_sc_hd__buf_2
XFILLER_0_79_402 VGND VGND VPWR VPWR sky130_fd_sc_hd__decap_4
X_4016_ _1369_ VGND VGND VPWR VPWR _0434_ sky130_fd_sc_hd__clkbuf_1
XFILLER_0_28_3 VPWR VGND VPWR VGND sky130_ef_sc_hd__decap_12
XANTENNA__3036__B2 _0685_ VGND VGND VPWR VPWR sky130_fd_sc_hd__diode_2
Xclkbuf_leaf_32_clk clknet_3_6__leaf_clk VGND VGND VPWR VPWR clknet_leaf_32_clk sky130_fd_sc_hd__clkbuf_4
XANTENNA__4754__RESET_B net13 VGND VGND VPWR VPWR sky130_fd_sc_hd__diode_2
X_4849_ clknet_leaf_32_clk _0530_ net13 VGND VGND VPWR VPWR tree_instances\[19\].u_tree.pipeline_current_node\[0\]\[4\]
+ sky130_fd_sc_hd__dfrtp_1
XFILLER_0_62_335 VGND VGND VPWR VPWR sky130_fd_sc_hd__decap_6
XTAP_TAPCELL_ROW_10_308 VGND VPWR sky130_fd_sc_hd__tapvpwrvgnd_1
XFILLER_0_7_473 VPWR VGND VPWR VGND sky130_ef_sc_hd__decap_12
XANTENNA__2974__A _0653_ VGND VGND VPWR VPWR sky130_fd_sc_hd__diode_2
XFILLER_0_85_416 VGND VGND VPWR VPWR sky130_fd_sc_hd__fill_1
XFILLER_0_85_449 VGND VGND VPWR VPWR sky130_fd_sc_hd__decap_4
XANTENNA__3027__A1 _0694_ VGND VGND VPWR VPWR sky130_fd_sc_hd__diode_2
XANTENNA__3027__B2 _0697_ VGND VGND VPWR VPWR sky130_fd_sc_hd__diode_2
XTAP_TAPCELL_ROW_54_750 VGND VPWR sky130_fd_sc_hd__tapvpwrvgnd_1
XANTENNA__4495__RESET_B net11 VGND VGND VPWR VPWR sky130_fd_sc_hd__diode_2
Xclkbuf_leaf_23_clk clknet_3_3__leaf_clk VGND VGND VPWR VPWR clknet_leaf_23_clk sky130_fd_sc_hd__clkbuf_4
XFILLER_0_38_365 VGND VGND VPWR VPWR sky130_fd_sc_hd__fill_2
XANTENNA__4424__RESET_B tree_instances\[0\].u_tree.rst_n VGND VGND VPWR VPWR sky130_fd_sc_hd__diode_2
XFILLER_0_38_376 VPWR VGND VPWR VGND sky130_ef_sc_hd__decap_12
XANTENNA__4374__SET_B net13 VGND VGND VPWR VPWR sky130_fd_sc_hd__diode_2
XFILLER_0_95_39 VPWR VGND VPWR VGND sky130_ef_sc_hd__decap_12
XFILLER_0_0_137 VGND VGND VPWR VPWR sky130_fd_sc_hd__decap_3
XANTENNA__3045__A _0650_ VGND VGND VPWR VPWR sky130_fd_sc_hd__diode_2
X_2200_ tree_instances\[9\].u_tree.pipeline_current_node\[0\]\[3\] tree_instances\[9\].u_tree.pipeline_current_node\[0\]\[4\]
+ VGND VGND VPWR VPWR _1580_ sky130_fd_sc_hd__or2_1
X_3180_ _0845_ _0847_ _0851_ VGND VGND VPWR VPWR _0852_ sky130_fd_sc_hd__and3_1
XFILLER_0_28_99 VGND VGND VPWR VPWR sky130_fd_sc_hd__fill_1
XFILLER_0_88_221 VGND VGND VPWR VPWR sky130_fd_sc_hd__fill_2
XANTENNA_clkbuf_leaf_62_clk_A clknet_3_1__leaf_clk VGND VGND VPWR VPWR sky130_fd_sc_hd__diode_2
XFILLER_0_44_65 VGND VGND VPWR VPWR sky130_fd_sc_hd__fill_1
XFILLER_0_17_505 VPWR VGND VPWR VGND sky130_ef_sc_hd__decap_12
XFILLER_0_29_343 VGND VGND VPWR VPWR sky130_fd_sc_hd__fill_1
X_2964_ current_voting_frame\[0\] VGND VGND VPWR VPWR _0646_ sky130_fd_sc_hd__inv_2
Xclkbuf_leaf_14_clk clknet_3_2__leaf_clk VGND VGND VPWR VPWR clknet_leaf_14_clk sky130_fd_sc_hd__clkbuf_4
X_4703_ clknet_leaf_2_clk _0406_ net9 VGND VGND VPWR VPWR tree_instances\[13\].u_tree.pipeline_current_node\[0\]\[7\]
+ sky130_fd_sc_hd__dfrtp_1
XFILLER_0_44_302 VGND VGND VPWR VPWR sky130_fd_sc_hd__fill_2
XFILLER_0_60_97 VGND VGND VPWR VPWR sky130_fd_sc_hd__decap_3
X_2895_ tree_instances\[13\].u_tree.tree_state\[0\] VGND VGND VPWR VPWR _0601_ sky130_fd_sc_hd__inv_2
XFILLER_0_44_346 VGND VGND VPWR VPWR sky130_fd_sc_hd__fill_2
XPHY_EDGE_ROW_62_Left_159 VGND VGND VPWR VPWR sky130_fd_sc_hd__decap_3
XFILLER_0_4_421 VPWR VGND VPWR VGND sky130_ef_sc_hd__decap_12
XFILLER_0_32_519 VPWR VGND VPWR VGND sky130_ef_sc_hd__decap_12
X_4634_ clknet_leaf_4_clk _0344_ tree_instances\[0\].u_tree.rst_n VGND VGND VPWR VPWR
+ tree_instances\[10\].u_tree.pipeline_frame_id\[0\]\[0\] sky130_fd_sc_hd__dfrtp_1
XFILLER_0_69_40 VGND VGND VPWR VPWR sky130_fd_sc_hd__fill_2
X_4565_ clknet_leaf_62_clk _0286_ net9 VGND VGND VPWR VPWR tree_instances\[7\].u_tree.pipeline_frame_id\[0\]\[3\]
+ sky130_fd_sc_hd__dfrtp_1
X_3516_ _1068_ VGND VGND VPWR VPWR _1069_ sky130_fd_sc_hd__clkbuf_1
XPHY_EDGE_ROW_4_Right_4 VGND VGND VPWR VPWR sky130_fd_sc_hd__decap_3
X_4496_ clknet_leaf_4_clk _0045_ tree_instances\[0\].u_tree.rst_n VGND VGND VPWR VPWR
+ tree_instances\[10\].u_tree.tree_state\[0\] sky130_fd_sc_hd__dfstp_1
X_3447_ _1022_ VGND VGND VPWR VPWR _1026_ sky130_fd_sc_hd__clkbuf_1
XFILLER_0_85_50 VGND VGND VPWR VPWR sky130_fd_sc_hd__decap_6
XANTENNA_clkbuf_leaf_15_clk_A clknet_3_2__leaf_clk VGND VGND VPWR VPWR sky130_fd_sc_hd__diode_2
X_3378_ tree_instances\[2\].u_tree.pipeline_frame_id\[0\]\[3\] _0925_ _0028_ VGND
+ VGND VPWR VPWR _0986_ sky130_fd_sc_hd__mux2_1
XPHY_EDGE_ROW_71_Left_168 VGND VGND VPWR VPWR sky130_fd_sc_hd__decap_3
X_2329_ _1694_ VGND VGND VPWR VPWR _1695_ sky130_fd_sc_hd__clkbuf_1
XTAP_TAPCELL_ROW_68_886 VGND VPWR sky130_fd_sc_hd__tapvpwrvgnd_1
XFILLER_0_79_276 VGND VGND VPWR VPWR sky130_fd_sc_hd__decap_4
XTAP_TAPCELL_ROW_80_1008 VGND VPWR sky130_fd_sc_hd__tapvpwrvgnd_1
XFILLER_0_67_449 VGND VGND VPWR VPWR sky130_fd_sc_hd__fill_2
XTAP_TAPCELL_ROW_51_720 VGND VPWR sky130_fd_sc_hd__tapvpwrvgnd_1
XFILLER_0_47_151 VGND VGND VPWR VPWR sky130_fd_sc_hd__fill_2
XFILLER_0_47_173 VGND VGND VPWR VPWR sky130_fd_sc_hd__fill_2
XFILLER_0_47_162 VGND VGND VPWR VPWR sky130_fd_sc_hd__decap_6
XPHY_EDGE_ROW_80_Left_177 VGND VGND VPWR VPWR sky130_fd_sc_hd__decap_3
XFILLER_0_62_121 VGND VGND VPWR VPWR sky130_fd_sc_hd__decap_6
XFILLER_0_7_281 VPWR VGND VPWR VGND sky130_ef_sc_hd__decap_12
XFILLER_0_50_305 VGND VGND VPWR VPWR sky130_fd_sc_hd__decap_3
XFILLER_0_50_338 VGND VGND VPWR VPWR sky130_fd_sc_hd__fill_2
XTAP_TAPCELL_ROW_91_1115 VGND VPWR sky130_fd_sc_hd__tapvpwrvgnd_1
XTAP_TAPCELL_ROW_89_1099 VGND VPWR sky130_fd_sc_hd__tapvpwrvgnd_1
XANTENNA__4676__RESET_B net12 VGND VGND VPWR VPWR sky130_fd_sc_hd__diode_2
XFILLER_0_58_449 VGND VGND VPWR VPWR sky130_fd_sc_hd__decap_4
XFILLER_0_14_35 VGND VGND VPWR VPWR sky130_fd_sc_hd__fill_1
XANTENNA__4605__RESET_B net9 VGND VGND VPWR VPWR sky130_fd_sc_hd__diode_2
XFILLER_0_14_57 VPWR VGND VPWR VGND sky130_ef_sc_hd__decap_12
XFILLER_0_14_79 VGND VGND VPWR VPWR sky130_fd_sc_hd__decap_4
XANTENNA__3420__A1 _0675_ VGND VGND VPWR VPWR sky130_fd_sc_hd__diode_2
X_2680_ _1864_ VGND VGND VPWR VPWR _2001_ sky130_fd_sc_hd__clkbuf_1
XFILLER_0_41_305 VPWR VGND VPWR VGND sky130_ef_sc_hd__decap_12
XFILLER_0_41_327 VGND VGND VPWR VPWR sky130_fd_sc_hd__fill_2
X_4350_ clknet_leaf_19_clk _0110_ net11 VGND VGND VPWR VPWR net6 sky130_fd_sc_hd__dfrtp_2
X_3301_ _0939_ VGND VGND VPWR VPWR _0149_ sky130_fd_sc_hd__clkbuf_1
XFILLER_0_39_21 VGND VGND VPWR VPWR sky130_fd_sc_hd__fill_1
X_4281_ _1729_ _1522_ _0016_ tree_instances\[16\].u_tree.pipeline_valid\[0\] VGND
+ VGND VPWR VPWR _0546_ sky130_fd_sc_hd__o2bb2a_1
XFILLER_0_39_87 VGND VGND VPWR VPWR sky130_fd_sc_hd__fill_2
XFILLER_0_39_98 VPWR VGND VPWR VGND sky130_ef_sc_hd__decap_12
Xclkbuf_leaf_3_clk clknet_3_0__leaf_clk VGND VGND VPWR VPWR clknet_leaf_3_clk sky130_fd_sc_hd__clkbuf_4
X_3232_ _0721_ _0899_ _0900_ VGND VGND VPWR VPWR _0901_ sky130_fd_sc_hd__nand3_1
X_3163_ _0697_ tree_instances\[11\].u_tree.frame_id_out\[4\] _0834_ VGND VGND VPWR
+ VPWR _0835_ sky130_fd_sc_hd__a21oi_1
X_3094_ _0648_ tree_instances\[1\].u_tree.frame_id_out\[0\] tree_instances\[1\].u_tree.frame_id_out\[4\]
+ _0697_ VGND VGND VPWR VPWR _0766_ sky130_fd_sc_hd__a22oi_1
XTAP_TAPCELL_ROW_65_856 VGND VPWR sky130_fd_sc_hd__tapvpwrvgnd_1
XFILLER_0_49_405 VGND VGND VPWR VPWR sky130_fd_sc_hd__decap_4
XFILLER_0_76_235 VGND VGND VPWR VPWR sky130_fd_sc_hd__decap_3
XANTENNA__4346__RESET_B tree_instances\[0\].u_tree.rst_n VGND VGND VPWR VPWR sky130_fd_sc_hd__diode_2
XFILLER_0_76_257 VGND VGND VPWR VPWR sky130_fd_sc_hd__decap_8
XFILLER_0_91_205 VPWR VGND VPWR VGND sky130_ef_sc_hd__decap_12
X_3996_ _1359_ VGND VGND VPWR VPWR _0424_ sky130_fd_sc_hd__clkbuf_1
XFILLER_0_91_249 VPWR VGND VPWR VGND sky130_ef_sc_hd__decap_12
XFILLER_0_84_290 VGND VGND VPWR VPWR sky130_fd_sc_hd__fill_2
XFILLER_0_72_430 VGND VGND VPWR VPWR sky130_fd_sc_hd__decap_3
X_2947_ _0634_ VGND VGND VPWR VPWR _0026_ sky130_fd_sc_hd__inv_2
XFILLER_0_95_3 VPWR VGND VPWR VGND sky130_ef_sc_hd__decap_12
X_2878_ _1801_ VGND VGND VPWR VPWR _0585_ sky130_fd_sc_hd__clkbuf_1
X_4617_ clknet_leaf_6_clk _0332_ tree_instances\[0\].u_tree.rst_n VGND VGND VPWR VPWR
+ tree_instances\[9\].u_tree.frame_id_out\[4\] sky130_fd_sc_hd__dfrtp_1
XFILLER_0_13_541 VPWR VGND VPWR VGND sky130_ef_sc_hd__decap_12
XFILLER_0_4_284 VGND VGND VPWR VPWR sky130_fd_sc_hd__fill_1
X_4548_ clknet_leaf_29_clk _0273_ net13 VGND VGND VPWR VPWR tree_instances\[0\].u_tree.pipeline_valid\[0\]
+ sky130_fd_sc_hd__dfrtp_1
X_4479_ clknet_leaf_63_clk _0219_ net9 VGND VGND VPWR VPWR tree_instances\[4\].u_tree.pipeline_frame_id\[0\]\[0\]
+ sky130_fd_sc_hd__dfrtp_1
XFILLER_0_40_393 VGND VGND VPWR VPWR sky130_fd_sc_hd__decap_3
XANTENNA__3478__A1 _0682_ VGND VGND VPWR VPWR sky130_fd_sc_hd__diode_2
XPHY_EDGE_ROW_79_Right_79 VGND VGND VPWR VPWR sky130_fd_sc_hd__decap_3
XTAP_TAPCELL_ROW_0_194 VGND VPWR sky130_fd_sc_hd__tapvpwrvgnd_1
XFILLER_0_67_279 VGND VGND VPWR VPWR sky130_fd_sc_hd__fill_1
XFILLER_0_48_460 VPWR VGND VPWR VGND sky130_ef_sc_hd__decap_12
XPHY_EDGE_ROW_88_Right_88 VGND VGND VPWR VPWR sky130_fd_sc_hd__decap_3
XFILLER_0_31_393 VGND VGND VPWR VPWR sky130_fd_sc_hd__decap_4
XANTENNA__4857__RESET_B net13 VGND VGND VPWR VPWR sky130_fd_sc_hd__diode_2
XFILLER_0_92_29 VGND VGND VPWR VPWR sky130_fd_sc_hd__decap_6
XFILLER_0_86_533 VPWR VGND VPWR VGND sky130_ef_sc_hd__decap_12
XTAP_TAPCELL_ROW_62_826 VGND VPWR sky130_fd_sc_hd__tapvpwrvgnd_1
XFILLER_0_58_246 VGND VGND VPWR VPWR sky130_fd_sc_hd__decap_6
X_3850_ tree_instances\[11\].u_tree.pipeline_frame_id\[0\]\[3\] _1192_ _0006_ VGND
+ VGND VPWR VPWR _1269_ sky130_fd_sc_hd__mux2_1
X_3781_ _1233_ VGND VGND VPWR VPWR _0335_ sky130_fd_sc_hd__clkbuf_1
X_2801_ tree_instances\[17\].u_tree.prediction_valid _1827_ VGND VGND VPWR VPWR _2106_
+ sky130_fd_sc_hd__and2b_1
X_2732_ _1649_ _2044_ VGND VGND VPWR VPWR _2045_ sky130_fd_sc_hd__and2_1
XFILLER_0_81_293 VPWR VGND VPWR VGND sky130_ef_sc_hd__decap_12
X_2663_ _1982_ VGND VGND VPWR VPWR _1985_ sky130_fd_sc_hd__clkbuf_1
X_4402_ clknet_leaf_21_clk _0149_ net11 VGND VGND VPWR VPWR tree_instances\[1\].u_tree.pipeline_current_node\[0\]\[2\]
+ sky130_fd_sc_hd__dfrtp_1
X_2594_ tree_instances\[1\].u_tree.tree_state\[2\] _1926_ tree_instances\[1\].u_tree.tree_state\[1\]
+ VGND VGND VPWR VPWR _0064_ sky130_fd_sc_hd__a21o_1
XFILLER_0_1_221 VGND VGND VPWR VPWR sky130_fd_sc_hd__decap_3
X_4333_ clknet_leaf_19_clk _0048_ net11 VGND VGND VPWR VPWR tree_instances\[12\].u_tree.tree_state\[0\]
+ sky130_fd_sc_hd__dfstp_1
XANTENNA__3217__B _0000_ VGND VGND VPWR VPWR sky130_fd_sc_hd__diode_2
XFILLER_0_10_533 VPWR VGND VPWR VGND sky130_ef_sc_hd__decap_12
X_4264_ _1514_ VGND VGND VPWR VPWR _0537_ sky130_fd_sc_hd__clkbuf_1
X_3215_ _0886_ VGND VGND VPWR VPWR _0116_ sky130_fd_sc_hd__inv_2
XFILLER_0_66_41 VGND VGND VPWR VPWR sky130_fd_sc_hd__decap_8
XANTENNA__4598__RESET_B net9 VGND VGND VPWR VPWR sky130_fd_sc_hd__diode_2
XFILLER_0_5_66 VPWR VGND VPWR VGND sky130_ef_sc_hd__decap_12
XFILLER_0_5_55 VGND VGND VPWR VPWR sky130_fd_sc_hd__fill_1
X_4195_ _1436_ _1478_ VGND VGND VPWR VPWR _1479_ sky130_fd_sc_hd__and2_1
XANTENNA__4527__RESET_B net11 VGND VGND VPWR VPWR sky130_fd_sc_hd__diode_2
X_3146_ tree_instances\[12\].u_tree.frame_id_out\[2\] VGND VGND VPWR VPWR _0818_ sky130_fd_sc_hd__inv_2
XTAP_TAPCELL_ROW_78_992 VGND VPWR sky130_fd_sc_hd__tapvpwrvgnd_1
X_3077_ tree_instances\[19\].u_tree.frame_id_out\[3\] VGND VGND VPWR VPWR _0749_ sky130_fd_sc_hd__inv_2
XFILLER_0_10_3 VPWR VGND VPWR VGND sky130_ef_sc_hd__decap_12
XFILLER_0_9_332 VGND VGND VPWR VPWR sky130_fd_sc_hd__decap_4
XFILLER_0_9_321 VGND VGND VPWR VPWR sky130_fd_sc_hd__decap_8
XFILLER_0_92_569 VGND VGND VPWR VPWR sky130_fd_sc_hd__decap_4
X_3979_ _1350_ VGND VGND VPWR VPWR _0416_ sky130_fd_sc_hd__clkbuf_1
XFILLER_0_45_485 VGND VGND VPWR VPWR sky130_fd_sc_hd__decap_6
XFILLER_0_13_371 VGND VGND VPWR VPWR sky130_fd_sc_hd__fill_2
XFILLER_0_13_393 VGND VGND VPWR VPWR sky130_fd_sc_hd__fill_1
XFILLER_0_87_308 VGND VGND VPWR VPWR sky130_fd_sc_hd__fill_2
XTAP_TAPCELL_ROW_86_1069 VGND VPWR sky130_fd_sc_hd__tapvpwrvgnd_1
XFILLER_0_11_14 VGND VGND VPWR VPWR sky130_fd_sc_hd__decap_8
XFILLER_0_36_441 VGND VGND VPWR VPWR sky130_fd_sc_hd__fill_1
XFILLER_0_23_113 VGND VGND VPWR VPWR sky130_fd_sc_hd__fill_1
XFILLER_0_36_485 VPWR VGND VPWR VGND sky130_ef_sc_hd__decap_12
XFILLER_0_11_69 VGND VGND VPWR VPWR sky130_fd_sc_hd__decap_8
XFILLER_0_51_488 VGND VGND VPWR VPWR sky130_fd_sc_hd__fill_2
XANTENNA__4691__RESET_B net12 VGND VGND VPWR VPWR sky130_fd_sc_hd__diode_2
X_3000_ _0674_ VGND VGND VPWR VPWR _0675_ sky130_fd_sc_hd__clkbuf_4
XTAP_TAPCELL_ROW_75_962 VGND VPWR sky130_fd_sc_hd__tapvpwrvgnd_1
XTAP_TAPCELL_ROW_19_399 VGND VPWR sky130_fd_sc_hd__tapvpwrvgnd_1
XTAP_TAPCELL_ROW_47_675 VGND VPWR sky130_fd_sc_hd__tapvpwrvgnd_1
X_3902_ _1303_ VGND VGND VPWR VPWR _0386_ sky130_fd_sc_hd__clkbuf_1
XFILLER_0_74_503 VGND VGND VPWR VPWR sky130_fd_sc_hd__decap_3
X_4882_ clknet_leaf_40_clk _0554_ net10 VGND VGND VPWR VPWR tree_instances\[20\].u_tree.pipeline_current_node\[0\]\[7\]
+ sky130_fd_sc_hd__dfrtp_1
X_3833_ _1608_ VGND VGND VPWR VPWR _1260_ sky130_fd_sc_hd__clkbuf_1
XFILLER_0_46_227 VGND VGND VPWR VPWR sky130_fd_sc_hd__fill_2
XFILLER_0_6_324 VGND VGND VPWR VPWR sky130_fd_sc_hd__decap_4
X_3764_ tree_instances\[9\].u_tree.frame_id_out\[0\] tree_instances\[9\].u_tree.pipeline_frame_id\[0\]\[0\]
+ _1649_ VGND VGND VPWR VPWR _1224_ sky130_fd_sc_hd__mux2_1
XFILLER_0_27_485 VGND VGND VPWR VPWR sky130_fd_sc_hd__decap_8
X_3695_ _1184_ VGND VGND VPWR VPWR _0298_ sky130_fd_sc_hd__clkbuf_1
X_2715_ tree_instances\[11\].u_tree.pipeline_current_node\[0\]\[5\] VGND VGND VPWR
+ VPWR _2031_ sky130_fd_sc_hd__clkbuf_1
X_2646_ tree_instances\[19\].u_tree.tree_state\[3\] VGND VGND VPWR VPWR _1970_ sky130_fd_sc_hd__buf_2
XANTENNA__4779__RESET_B net13 VGND VGND VPWR VPWR sky130_fd_sc_hd__diode_2
XFILLER_0_58_3 VPWR VGND VPWR VGND sky130_ef_sc_hd__decap_12
X_2577_ _1909_ _1910_ tree_instances\[3\].u_tree.tree_state\[2\] VGND VGND VPWR VPWR
+ _0029_ sky130_fd_sc_hd__o21a_1
XFILLER_0_10_330 VPWR VGND VPWR VGND sky130_ef_sc_hd__decap_12
X_4316_ tree_instances\[20\].u_tree.frame_id_out\[2\] tree_instances\[20\].u_tree.pipeline_frame_id\[0\]\[2\]
+ _1908_ VGND VGND VPWR VPWR _1541_ sky130_fd_sc_hd__mux2_1
XANTENNA__4708__RESET_B net9 VGND VGND VPWR VPWR sky130_fd_sc_hd__diode_2
X_4247_ _1981_ _1502_ VGND VGND VPWR VPWR _1506_ sky130_fd_sc_hd__and2_1
X_4178_ tree_instances\[17\].u_tree.pipeline_frame_id\[0\]\[4\] tree_instances\[0\].u_tree.frame_id_in\[4\]
+ _0018_ VGND VGND VPWR VPWR _1470_ sky130_fd_sc_hd__mux2_1
XANTENNA__4361__RESET_B net12 VGND VGND VPWR VPWR sky130_fd_sc_hd__diode_2
XFILLER_0_93_61 VGND VGND VPWR VPWR sky130_fd_sc_hd__fill_1
X_3129_ _0704_ tree_instances\[3\].u_tree.frame_id_out\[2\] tree_instances\[3\].u_tree.frame_id_out\[4\]
+ _0696_ _0800_ VGND VGND VPWR VPWR _0801_ sky130_fd_sc_hd__o221a_1
XFILLER_0_77_341 VGND VGND VPWR VPWR sky130_fd_sc_hd__decap_8
XFILLER_0_77_363 VGND VGND VPWR VPWR sky130_fd_sc_hd__fill_2
XFILLER_0_65_514 VPWR VGND VPWR VGND sky130_ef_sc_hd__decap_12
XFILLER_0_37_205 VGND VGND VPWR VPWR sky130_fd_sc_hd__fill_2
XFILLER_0_9_140 VGND VGND VPWR VPWR sky130_fd_sc_hd__decap_8
XFILLER_0_20_116 VGND VGND VPWR VPWR sky130_fd_sc_hd__fill_2
XANTENNA__4449__RESET_B tree_instances\[0\].u_tree.rst_n VGND VGND VPWR VPWR sky130_fd_sc_hd__diode_2
XANTENNA__3844__A1 _1162_ VGND VGND VPWR VPWR sky130_fd_sc_hd__diode_2
XTAP_TAPCELL_ROW_72_932 VGND VPWR sky130_fd_sc_hd__tapvpwrvgnd_1
XFILLER_0_95_160 VGND VGND VPWR VPWR sky130_fd_sc_hd__fill_1
XFILLER_0_68_374 VGND VGND VPWR VPWR sky130_fd_sc_hd__fill_2
XTAP_TAPCELL_ROW_44_645 VGND VPWR sky130_fd_sc_hd__tapvpwrvgnd_1
XTAP_TAPCELL_ROW_16_369 VGND VPWR sky130_fd_sc_hd__tapvpwrvgnd_1
XFILLER_0_56_547 VGND VGND VPWR VPWR sky130_fd_sc_hd__fill_2
XFILLER_0_43_219 VGND VGND VPWR VPWR sky130_fd_sc_hd__decap_3
XFILLER_0_3_305 VPWR VGND VPWR VGND sky130_ef_sc_hd__decap_12
X_2500_ tree_instances\[3\].u_tree.pipeline_current_node\[0\]\[4\] VGND VGND VPWR
+ VPWR _1846_ sky130_fd_sc_hd__inv_2
X_3480_ tree_instances\[4\].u_tree.frame_id_out\[0\] tree_instances\[4\].u_tree.pipeline_frame_id\[0\]\[0\]
+ _1834_ VGND VGND VPWR VPWR _1044_ sky130_fd_sc_hd__mux2_1
XFILLER_0_24_477 VPWR VGND VPWR VGND sky130_ef_sc_hd__decap_12
X_2431_ _1783_ _1784_ VGND VGND VPWR VPWR _1785_ sky130_fd_sc_hd__nor2_1
XANTENNA__4872__RESET_B net10 VGND VGND VPWR VPWR sky130_fd_sc_hd__diode_2
XFILLER_0_11_149 VGND VGND VPWR VPWR sky130_fd_sc_hd__fill_1
X_2362_ _1721_ _1724_ VGND VGND VPWR VPWR _1725_ sky130_fd_sc_hd__nand2_1
XANTENNA__4801__RESET_B net13 VGND VGND VPWR VPWR sky130_fd_sc_hd__diode_2
X_2293_ tree_instances\[8\].u_tree.pipeline_current_node\[0\]\[8\] _1663_ VGND VGND
+ VPWR VPWR _1664_ sky130_fd_sc_hd__nor2_1
X_4101_ _1413_ VGND VGND VPWR VPWR _0475_ sky130_fd_sc_hd__clkbuf_1
XFILLER_0_47_54 VGND VGND VPWR VPWR sky130_fd_sc_hd__fill_2
X_4032_ _1321_ _1376_ VGND VGND VPWR VPWR _1378_ sky130_fd_sc_hd__and2_1
XFILLER_0_59_385 VGND VGND VPWR VPWR sky130_fd_sc_hd__decap_6
X_4865_ clknet_leaf_28_clk _0095_ net13 VGND VGND VPWR VPWR tree_instances\[19\].u_tree.prediction_valid
+ sky130_fd_sc_hd__dfrtp_1
XFILLER_0_19_249 VGND VGND VPWR VPWR sky130_fd_sc_hd__decap_4
XFILLER_0_47_558 VGND VGND VPWR VPWR sky130_fd_sc_hd__fill_2
XFILLER_0_47_569 VGND VGND VPWR VPWR sky130_fd_sc_hd__decap_4
XFILLER_0_74_399 VGND VGND VPWR VPWR sky130_fd_sc_hd__fill_1
X_4796_ clknet_leaf_54_clk _0483_ tree_instances\[0\].u_tree.rst_n VGND VGND VPWR
+ VPWR tree_instances\[17\].u_tree.pipeline_current_node\[0\]\[0\] sky130_fd_sc_hd__dfrtp_1
X_3816_ tree_instances\[10\].u_tree.frame_id_out\[4\] tree_instances\[10\].u_tree.pipeline_frame_id\[0\]\[4\]
+ tree_instances\[10\].u_tree.tree_state\[3\] VGND VGND VPWR VPWR _1251_ sky130_fd_sc_hd__mux2_1
X_3747_ _1215_ VGND VGND VPWR VPWR _0319_ sky130_fd_sc_hd__clkbuf_1
XFILLER_0_42_241 VGND VGND VPWR VPWR sky130_fd_sc_hd__fill_2
XFILLER_0_15_499 VGND VGND VPWR VPWR sky130_fd_sc_hd__decap_4
X_3678_ tree_instances\[7\].u_tree.frame_id_out\[4\] tree_instances\[7\].u_tree.pipeline_frame_id\[0\]\[4\]
+ tree_instances\[7\].u_tree.tree_state\[3\] VGND VGND VPWR VPWR _1174_ sky130_fd_sc_hd__mux2_1
X_2629_ _1953_ _1954_ VGND VGND VPWR VPWR _1955_ sky130_fd_sc_hd__nor2_1
XTAP_TAPCELL_ROW_83_1039 VGND VPWR sky130_fd_sc_hd__tapvpwrvgnd_1
XFILLER_0_38_514 VGND VGND VPWR VPWR sky130_fd_sc_hd__decap_6
XTAP_TAPCELL_ROW_41_615 VGND VPWR sky130_fd_sc_hd__tapvpwrvgnd_1
XFILLER_0_92_152 VPWR VGND VPWR VGND sky130_ef_sc_hd__decap_12
XFILLER_0_92_141 VGND VGND VPWR VPWR sky130_fd_sc_hd__decap_3
XTAP_TAPCELL_ROW_13_339 VGND VPWR sky130_fd_sc_hd__tapvpwrvgnd_1
XFILLER_0_53_517 VPWR VGND VPWR VGND sky130_ef_sc_hd__decap_12
XFILLER_0_80_369 VGND VGND VPWR VPWR sky130_fd_sc_hd__fill_1
XFILLER_0_61_561 VPWR VGND VPWR VGND sky130_ef_sc_hd__decap_12
XTAP_TAPCELL_ROW_94_1146 VGND VPWR sky130_fd_sc_hd__tapvpwrvgnd_1
XFILLER_0_17_35 VGND VGND VPWR VPWR sky130_fd_sc_hd__decap_6
XFILLER_0_88_469 VGND VGND VPWR VPWR sky130_fd_sc_hd__fill_1
XANTENNA__4397__SET_B net13 VGND VGND VPWR VPWR sky130_fd_sc_hd__diode_2
XTAP_TAPCELL_ROW_57_781 VGND VPWR sky130_fd_sc_hd__tapvpwrvgnd_1
XTAP_TAPCELL_ROW_29_494 VGND VPWR sky130_fd_sc_hd__tapvpwrvgnd_1
X_2980_ _0658_ net5 _0645_ VGND VGND VPWR VPWR _0659_ sky130_fd_sc_hd__mux2_1
XFILLER_0_68_171 VGND VGND VPWR VPWR sky130_fd_sc_hd__fill_1
XFILLER_0_56_322 VGND VGND VPWR VPWR sky130_fd_sc_hd__fill_2
XFILLER_0_33_78 VGND VGND VPWR VPWR sky130_fd_sc_hd__fill_2
XFILLER_0_33_89 VGND VGND VPWR VPWR sky130_fd_sc_hd__fill_2
XFILLER_0_16_219 VPWR VGND VPWR VGND sky130_ef_sc_hd__decap_12
X_4650_ clknet_leaf_68_clk _0355_ net9 VGND VGND VPWR VPWR tree_instances\[7\].u_tree.pipeline_valid\[0\]
+ sky130_fd_sc_hd__dfrtp_1
XFILLER_0_56_388 VGND VGND VPWR VPWR sky130_fd_sc_hd__decap_8
X_3601_ _1125_ VGND VGND VPWR VPWR _0263_ sky130_fd_sc_hd__clkbuf_1
XFILLER_0_3_102 VGND VGND VPWR VPWR sky130_fd_sc_hd__decap_3
X_4581_ clknet_leaf_15_clk _0301_ net12 VGND VGND VPWR VPWR tree_instances\[8\].u_tree.pipeline_current_node\[0\]\[7\]
+ sky130_fd_sc_hd__dfrtp_1
X_3532_ _1079_ VGND VGND VPWR VPWR _0240_ sky130_fd_sc_hd__clkbuf_1
X_3463_ _1035_ VGND VGND VPWR VPWR _0215_ sky130_fd_sc_hd__clkbuf_1
X_2414_ _1769_ VGND VGND VPWR VPWR _0005_ sky130_fd_sc_hd__clkbuf_1
X_3394_ tree_instances\[14\].u_tree.tree_state\[0\] _1888_ VGND VGND VPWR VPWR _0994_
+ sky130_fd_sc_hd__nand2_1
XFILLER_0_20_480 VGND VGND VPWR VPWR sky130_fd_sc_hd__decap_6
X_2345_ _1708_ VGND VGND VPWR VPWR _1709_ sky130_fd_sc_hd__clkbuf_1
X_2276_ _1574_ tree_instances\[9\].u_tree.pipeline_valid\[0\] VGND VGND VPWR VPWR
+ _1648_ sky130_fd_sc_hd__or2_1
XFILLER_0_74_85 VPWR VGND VPWR VGND sky130_ef_sc_hd__decap_12
X_4015_ tree_instances\[14\].u_tree.frame_id_out\[0\] tree_instances\[14\].u_tree.pipeline_frame_id\[0\]\[0\]
+ _1889_ VGND VGND VPWR VPWR _1369_ sky130_fd_sc_hd__mux2_1
XANTENNA__3241__A _0651_ VGND VGND VPWR VPWR sky130_fd_sc_hd__diode_2
XFILLER_0_79_469 VGND VGND VPWR VPWR sky130_fd_sc_hd__fill_2
XFILLER_0_94_428 VGND VGND VPWR VPWR sky130_fd_sc_hd__fill_1
XFILLER_0_47_300 VGND VGND VPWR VPWR sky130_fd_sc_hd__fill_1
XFILLER_0_47_322 VGND VGND VPWR VPWR sky130_fd_sc_hd__fill_2
XFILLER_0_74_141 VGND VGND VPWR VPWR sky130_fd_sc_hd__decap_4
XFILLER_0_74_130 VGND VGND VPWR VPWR sky130_fd_sc_hd__decap_8
X_4848_ clknet_leaf_32_clk _0529_ net10 VGND VGND VPWR VPWR tree_instances\[19\].u_tree.pipeline_current_node\[0\]\[3\]
+ sky130_fd_sc_hd__dfrtp_1
XFILLER_0_74_174 VGND VGND VPWR VPWR sky130_fd_sc_hd__decap_4
XFILLER_0_74_163 VGND VGND VPWR VPWR sky130_fd_sc_hd__decap_4
XFILLER_0_74_152 VGND VGND VPWR VPWR sky130_fd_sc_hd__fill_2
XFILLER_0_35_528 VPWR VGND VPWR VGND sky130_ef_sc_hd__decap_12
XANTENNA__4794__RESET_B net13 VGND VGND VPWR VPWR sky130_fd_sc_hd__diode_2
XTAP_TAPCELL_ROW_10_309 VGND VPWR sky130_fd_sc_hd__tapvpwrvgnd_1
XFILLER_0_7_485 VPWR VGND VPWR VGND sky130_ef_sc_hd__decap_12
X_4779_ clknet_leaf_51_clk _0467_ net13 VGND VGND VPWR VPWR tree_instances\[16\].u_tree.pipeline_current_node\[0\]\[5\]
+ sky130_fd_sc_hd__dfrtp_1
XFILLER_0_43_561 VPWR VGND VPWR VGND sky130_ef_sc_hd__decap_12
XANTENNA__4723__RESET_B net10 VGND VGND VPWR VPWR sky130_fd_sc_hd__diode_2
XANTENNA__4011__S _0012_ VGND VGND VPWR VPWR sky130_fd_sc_hd__diode_2
XFILLER_0_11_491 VPWR VGND VPWR VGND sky130_ef_sc_hd__decap_12
XFILLER_0_57_108 VGND VGND VPWR VPWR sky130_fd_sc_hd__decap_4
XTAP_TAPCELL_ROW_26_464 VGND VPWR sky130_fd_sc_hd__tapvpwrvgnd_1
XTAP_TAPCELL_ROW_54_751 VGND VPWR sky130_fd_sc_hd__tapvpwrvgnd_1
XFILLER_0_38_388 VGND VGND VPWR VPWR sky130_fd_sc_hd__decap_3
XANTENNA__4464__RESET_B net9 VGND VGND VPWR VPWR sky130_fd_sc_hd__diode_2
XFILLER_0_34_572 VGND VGND VPWR VPWR sky130_fd_sc_hd__fill_2
XANTENNA__3760__S _0042_ VGND VGND VPWR VPWR sky130_fd_sc_hd__diode_2
XANTENNA__3061__A _0650_ VGND VGND VPWR VPWR sky130_fd_sc_hd__diode_2
XFILLER_0_44_33 VGND VGND VPWR VPWR sky130_fd_sc_hd__decap_4
XFILLER_0_76_406 VGND VGND VPWR VPWR sky130_fd_sc_hd__fill_2
XANTENNA__4215__A1 _0672_ VGND VGND VPWR VPWR sky130_fd_sc_hd__diode_2
XFILLER_0_44_99 VGND VGND VPWR VPWR sky130_fd_sc_hd__fill_1
X_2963_ _1647_ VGND VGND VPWR VPWR _0645_ sky130_fd_sc_hd__clkbuf_4
XFILLER_0_56_141 VGND VGND VPWR VPWR sky130_fd_sc_hd__decap_6
XFILLER_0_60_32 VGND VGND VPWR VPWR sky130_fd_sc_hd__fill_2
XFILLER_0_17_517 VPWR VGND VPWR VGND sky130_ef_sc_hd__decap_12
X_4702_ clknet_leaf_0_clk _0405_ net9 VGND VGND VPWR VPWR tree_instances\[13\].u_tree.pipeline_current_node\[0\]\[6\]
+ sky130_fd_sc_hd__dfrtp_1
XFILLER_0_71_133 VGND VGND VPWR VPWR sky130_fd_sc_hd__fill_1
X_2894_ _0600_ VGND VGND VPWR VPWR _0097_ sky130_fd_sc_hd__clkbuf_1
XFILLER_0_4_433 VPWR VGND VPWR VGND sky130_ef_sc_hd__decap_12
XFILLER_0_25_561 VPWR VGND VPWR VGND sky130_ef_sc_hd__decap_12
X_4633_ clknet_leaf_3_clk _0343_ tree_instances\[0\].u_tree.rst_n VGND VGND VPWR VPWR
+ tree_instances\[10\].u_tree.pipeline_current_node\[0\]\[8\] sky130_fd_sc_hd__dfrtp_1
XFILLER_0_44_358 VGND VGND VPWR VPWR sky130_fd_sc_hd__fill_2
XFILLER_0_71_177 VGND VGND VPWR VPWR sky130_fd_sc_hd__fill_1
X_4564_ clknet_leaf_5_clk _0285_ net9 VGND VGND VPWR VPWR tree_instances\[7\].u_tree.pipeline_frame_id\[0\]\[2\]
+ sky130_fd_sc_hd__dfrtp_1
XFILLER_0_12_222 VGND VGND VPWR VPWR sky130_fd_sc_hd__fill_2
XFILLER_0_8_88 VGND VGND VPWR VPWR sky130_fd_sc_hd__fill_1
XFILLER_0_4_477 VPWR VGND VPWR VGND sky130_ef_sc_hd__decap_12
X_3515_ _1758_ VGND VGND VPWR VPWR _1068_ sky130_fd_sc_hd__clkbuf_1
X_4495_ clknet_leaf_19_clk _0230_ net11 VGND VGND VPWR VPWR tree_instances\[12\].u_tree.pipeline_valid\[0\]
+ sky130_fd_sc_hd__dfrtp_1
XFILLER_0_69_96 VGND VGND VPWR VPWR sky130_fd_sc_hd__fill_2
XFILLER_0_12_266 VPWR VGND VPWR VGND sky130_ef_sc_hd__decap_12
X_3446_ _1019_ VGND VGND VPWR VPWR _1025_ sky130_fd_sc_hd__clkbuf_1
X_3377_ _0985_ VGND VGND VPWR VPWR _0179_ sky130_fd_sc_hd__clkbuf_1
XFILLER_0_85_95 VGND VGND VPWR VPWR sky130_fd_sc_hd__fill_2
X_2328_ _1693_ VGND VGND VPWR VPWR _1694_ sky130_fd_sc_hd__clkbuf_1
X_2259_ _1631_ _1633_ VGND VGND VPWR VPWR _1634_ sky130_fd_sc_hd__nand2_1
XTAP_TAPCELL_ROW_68_887 VGND VPWR sky130_fd_sc_hd__tapvpwrvgnd_1
XANTENNA__3293__A1_N _1827_ VGND VGND VPWR VPWR sky130_fd_sc_hd__diode_2
XFILLER_0_67_417 VGND VGND VPWR VPWR sky130_fd_sc_hd__fill_1
XTAP_TAPCELL_ROW_80_1009 VGND VPWR sky130_fd_sc_hd__tapvpwrvgnd_1
XTAP_TAPCELL_ROW_51_721 VGND VPWR sky130_fd_sc_hd__tapvpwrvgnd_1
XFILLER_0_75_461 VGND VGND VPWR VPWR sky130_fd_sc_hd__decap_8
XTAP_TAPCELL_ROW_23_434 VGND VPWR sky130_fd_sc_hd__tapvpwrvgnd_1
XFILLER_0_62_155 VGND VGND VPWR VPWR sky130_fd_sc_hd__fill_2
XFILLER_0_7_293 VPWR VGND VPWR VGND sky130_ef_sc_hd__decap_12
XFILLER_0_43_391 VGND VGND VPWR VPWR sky130_fd_sc_hd__fill_1
XTAP_TAPCELL_ROW_91_1116 VGND VPWR sky130_fd_sc_hd__tapvpwrvgnd_1
XFILLER_0_31_564 VGND VGND VPWR VPWR sky130_fd_sc_hd__decap_8
XFILLER_0_85_225 VPWR VGND VPWR VGND sky130_ef_sc_hd__decap_12
XFILLER_0_14_69 VGND VGND VPWR VPWR sky130_fd_sc_hd__decap_4
XFILLER_0_26_303 VGND VGND VPWR VPWR sky130_fd_sc_hd__fill_2
XFILLER_0_38_141 VGND VGND VPWR VPWR sky130_fd_sc_hd__fill_2
XANTENNA__4645__RESET_B tree_instances\[0\].u_tree.rst_n VGND VGND VPWR VPWR sky130_fd_sc_hd__diode_2
XFILLER_0_66_494 VGND VGND VPWR VPWR sky130_fd_sc_hd__fill_2
XFILLER_0_53_133 VGND VGND VPWR VPWR sky130_fd_sc_hd__decap_6
XFILLER_0_41_317 VGND VGND VPWR VPWR sky130_fd_sc_hd__decap_4
X_3300_ _0569_ _0936_ VGND VGND VPWR VPWR _0939_ sky130_fd_sc_hd__and2_1
X_4280_ tree_instances\[16\].u_tree.pipeline_valid\[0\] tree_instances\[16\].u_tree.tree_state\[0\]
+ VGND VGND VPWR VPWR _1522_ sky130_fd_sc_hd__nand2_1
X_3231_ complete_votes\[3\] _0809_ VGND VGND VPWR VPWR _0900_ sky130_fd_sc_hd__nand2_1
X_3162_ _0733_ tree_instances\[11\].u_tree.frame_id_out\[1\] VGND VGND VPWR VPWR _0834_
+ sky130_fd_sc_hd__xor2_1
X_3093_ _0740_ _0747_ _0756_ _0764_ VGND VGND VPWR VPWR _0765_ sky130_fd_sc_hd__and4bb_1
XTAP_TAPCELL_ROW_65_857 VGND VPWR sky130_fd_sc_hd__tapvpwrvgnd_1
XFILLER_0_9_503 VGND VGND VPWR VPWR sky130_fd_sc_hd__fill_1
XFILLER_0_91_217 VGND VGND VPWR VPWR sky130_fd_sc_hd__decap_6
XANTENNA__4386__RESET_B net10 VGND VGND VPWR VPWR sky130_fd_sc_hd__diode_2
X_3995_ _1291_ _1354_ VGND VGND VPWR VPWR _1359_ sky130_fd_sc_hd__and2_1
XFILLER_0_71_75 VGND VGND VPWR VPWR sky130_fd_sc_hd__fill_2
X_2946_ _0633_ _1907_ VGND VGND VPWR VPWR _0634_ sky130_fd_sc_hd__or2_1
XTAP_TAPCELL_ROW_20_404 VGND VPWR sky130_fd_sc_hd__tapvpwrvgnd_1
X_2877_ _0583_ VGND VGND VPWR VPWR _0584_ sky130_fd_sc_hd__clkbuf_1
XFILLER_0_88_3 VPWR VGND VPWR VGND sky130_ef_sc_hd__decap_12
XFILLER_0_72_497 VPWR VGND VPWR VGND sky130_ef_sc_hd__decap_12
X_4616_ clknet_leaf_8_clk _0331_ tree_instances\[0\].u_tree.rst_n VGND VGND VPWR VPWR
+ tree_instances\[9\].u_tree.frame_id_out\[3\] sky130_fd_sc_hd__dfrtp_1
XFILLER_0_13_553 VGND VGND VPWR VPWR sky130_fd_sc_hd__decap_6
XANTENNA__3175__B2 _0690_ VGND VGND VPWR VPWR sky130_fd_sc_hd__diode_2
XANTENNA__3175__A1 _0704_ VGND VGND VPWR VPWR sky130_fd_sc_hd__diode_2
X_4547_ clknet_leaf_58_clk _0074_ net12 VGND VGND VPWR VPWR tree_instances\[5\].u_tree.tree_state\[3\]
+ sky130_fd_sc_hd__dfrtp_1
X_4478_ clknet_leaf_65_clk _0218_ net9 VGND VGND VPWR VPWR tree_instances\[4\].u_tree.pipeline_current_node\[0\]\[8\]
+ sky130_fd_sc_hd__dfrtp_1
X_3429_ _1012_ VGND VGND VPWR VPWR _0204_ sky130_fd_sc_hd__clkbuf_1
XANTENNA__4741__SET_B net10 VGND VGND VPWR VPWR sky130_fd_sc_hd__diode_2
XFILLER_0_67_203 VGND VGND VPWR VPWR sky130_fd_sc_hd__decap_6
XFILLER_0_95_567 VGND VGND VPWR VPWR sky130_fd_sc_hd__fill_1
XTAP_TAPCELL_ROW_0_195 VGND VPWR sky130_fd_sc_hd__tapvpwrvgnd_1
XTAP_TAPCELL_ROW_36_570 VGND VPWR sky130_fd_sc_hd__tapvpwrvgnd_1
XFILLER_0_48_472 VGND VGND VPWR VPWR sky130_fd_sc_hd__fill_2
XFILLER_0_82_228 VPWR VGND VPWR VGND sky130_ef_sc_hd__decap_12
XFILLER_0_63_486 VGND VGND VPWR VPWR sky130_fd_sc_hd__fill_2
XFILLER_0_35_166 VGND VGND VPWR VPWR sky130_fd_sc_hd__fill_2
XFILLER_0_90_294 VGND VGND VPWR VPWR sky130_fd_sc_hd__decap_6
XFILLER_0_31_372 VPWR VGND VPWR VGND sky130_ef_sc_hd__decap_12
XANTENNA_clkbuf_leaf_61_clk_A clknet_3_1__leaf_clk VGND VGND VPWR VPWR sky130_fd_sc_hd__diode_2
XTAP_TAPCELL_ROW_8_284 VGND VPWR sky130_fd_sc_hd__tapvpwrvgnd_1
XANTENNA__4897__RESET_B net11 VGND VGND VPWR VPWR sky130_fd_sc_hd__diode_2
XFILLER_0_25_35 VGND VGND VPWR VPWR sky130_fd_sc_hd__fill_1
XANTENNA__4826__RESET_B net10 VGND VGND VPWR VPWR sky130_fd_sc_hd__diode_2
XFILLER_0_86_545 VPWR VGND VPWR VGND sky130_ef_sc_hd__decap_12
XTAP_TAPCELL_ROW_62_827 VGND VPWR sky130_fd_sc_hd__tapvpwrvgnd_1
XFILLER_0_39_461 VGND VGND VPWR VPWR sky130_fd_sc_hd__fill_1
X_2800_ _2093_ VGND VGND VPWR VPWR _2105_ sky130_fd_sc_hd__clkbuf_1
X_3780_ _0597_ _1232_ VGND VGND VPWR VPWR _1233_ sky130_fd_sc_hd__and2_1
XFILLER_0_39_483 VPWR VGND VPWR VGND sky130_ef_sc_hd__decap_12
XANTENNA_clkbuf_leaf_14_clk_A clknet_3_2__leaf_clk VGND VGND VPWR VPWR sky130_fd_sc_hd__diode_2
XFILLER_0_41_78 VGND VGND VPWR VPWR sky130_fd_sc_hd__decap_3
X_2731_ tree_instances\[9\].u_tree.prediction_valid VGND VGND VPWR VPWR _2044_ sky130_fd_sc_hd__inv_2
XFILLER_0_54_442 VGND VGND VPWR VPWR sky130_fd_sc_hd__fill_2
XFILLER_0_14_317 VGND VGND VPWR VPWR sky130_fd_sc_hd__fill_2
X_2662_ _1983_ VGND VGND VPWR VPWR _1984_ sky130_fd_sc_hd__clkbuf_1
X_4401_ clknet_leaf_31_clk _0148_ net11 VGND VGND VPWR VPWR tree_instances\[1\].u_tree.pipeline_current_node\[0\]\[1\]
+ sky130_fd_sc_hd__dfrtp_1
XFILLER_0_41_158 VGND VGND VPWR VPWR sky130_fd_sc_hd__fill_1
XANTENNA__3157__A1 _0694_ VGND VGND VPWR VPWR sky130_fd_sc_hd__diode_2
X_2593_ _1914_ _1921_ _1925_ VGND VGND VPWR VPWR _1926_ sky130_fd_sc_hd__nor3_1
XANTENNA_clkbuf_leaf_29_clk_A clknet_3_6__leaf_clk VGND VGND VPWR VPWR sky130_fd_sc_hd__diode_2
XFILLER_0_41_169 VPWR VGND VPWR VGND sky130_ef_sc_hd__decap_12
XANTENNA__3157__B2 _0696_ VGND VGND VPWR VPWR sky130_fd_sc_hd__diode_2
XFILLER_0_10_545 VPWR VGND VPWR VGND sky130_ef_sc_hd__decap_12
X_4332_ clknet_leaf_0_clk _0051_ net9 VGND VGND VPWR VPWR tree_instances\[13\].u_tree.tree_state\[3\]
+ sky130_fd_sc_hd__dfrtp_1
X_4263_ tree_instances\[19\].u_tree.pipeline_frame_id\[0\]\[2\] _0674_ _0022_ VGND
+ VGND VPWR VPWR _1514_ sky130_fd_sc_hd__mux2_1
X_3214_ complete_votes\[0\] _0683_ _0885_ VGND VGND VPWR VPWR _0886_ sky130_fd_sc_hd__mux2_1
XFILLER_0_5_78 VPWR VGND VPWR VGND sky130_ef_sc_hd__decap_12
X_4194_ _1477_ VGND VGND VPWR VPWR _1478_ sky130_fd_sc_hd__buf_1
X_3145_ _0810_ _0812_ _0816_ VGND VGND VPWR VPWR _0817_ sky130_fd_sc_hd__and3b_1
XFILLER_0_96_309 VPWR VGND VPWR VGND sky130_ef_sc_hd__decap_12
XFILLER_0_82_41 VGND VGND VPWR VPWR sky130_fd_sc_hd__fill_1
XTAP_TAPCELL_ROW_78_993 VGND VPWR sky130_fd_sc_hd__tapvpwrvgnd_1
X_3076_ tree_instances\[19\].u_tree.frame_id_out\[2\] VGND VGND VPWR VPWR _0748_ sky130_fd_sc_hd__inv_2
XFILLER_0_89_361 VGND VGND VPWR VPWR sky130_fd_sc_hd__decap_3
XFILLER_0_77_501 VGND VGND VPWR VPWR sky130_fd_sc_hd__decap_3
XANTENNA__4567__RESET_B tree_instances\[0\].u_tree.rst_n VGND VGND VPWR VPWR sky130_fd_sc_hd__diode_2
XFILLER_0_82_85 VPWR VGND VPWR VGND sky130_ef_sc_hd__decap_12
XFILLER_0_49_225 VGND VGND VPWR VPWR sky130_fd_sc_hd__fill_2
XFILLER_0_92_504 VGND VGND VPWR VPWR sky130_fd_sc_hd__fill_2
XTAP_TAPCELL_ROW_33_540 VGND VPWR sky130_fd_sc_hd__tapvpwrvgnd_1
X_3978_ tree_instances\[13\].u_tree.frame_id_out\[3\] tree_instances\[13\].u_tree.pipeline_frame_id\[0\]\[3\]
+ _1577_ VGND VGND VPWR VPWR _1350_ sky130_fd_sc_hd__mux2_1
XFILLER_0_45_431 VPWR VGND VPWR VGND sky130_ef_sc_hd__decap_12
XTAP_TAPCELL_ROW_79_1000 VGND VPWR sky130_fd_sc_hd__tapvpwrvgnd_1
X_2929_ tree_instances\[5\].u_tree.tree_state\[0\] VGND VGND VPWR VPWR _0623_ sky130_fd_sc_hd__inv_2
XFILLER_0_60_434 VGND VGND VPWR VPWR sky130_fd_sc_hd__fill_1
XFILLER_0_5_561 VPWR VGND VPWR VGND sky130_ef_sc_hd__decap_12
XFILLER_0_32_136 VGND VGND VPWR VPWR sky130_fd_sc_hd__fill_2
XFILLER_0_20_309 VPWR VGND VPWR VGND sky130_ef_sc_hd__decap_12
XTAP_TAPCELL_ROW_5_254 VGND VPWR sky130_fd_sc_hd__tapvpwrvgnd_1
XANTENNA__3320__A1 _0925_ VGND VGND VPWR VPWR sky130_fd_sc_hd__diode_2
XFILLER_0_95_331 VGND VGND VPWR VPWR sky130_fd_sc_hd__fill_2
XFILLER_0_83_559 VGND VGND VPWR VPWR sky130_fd_sc_hd__fill_1
XFILLER_0_70_209 VGND VGND VPWR VPWR sky130_fd_sc_hd__fill_2
XFILLER_0_36_497 VPWR VGND VPWR VGND sky130_ef_sc_hd__decap_12
XANTENNA__3139__A1 _0647_ VGND VGND VPWR VPWR sky130_fd_sc_hd__diode_2
XANTENNA__3139__B2 _0704_ VGND VGND VPWR VPWR sky130_fd_sc_hd__diode_2
XFILLER_0_36_67 VGND VGND VPWR VPWR sky130_fd_sc_hd__fill_2
XTAP_TAPCELL_ROW_75_963 VGND VPWR sky130_fd_sc_hd__tapvpwrvgnd_1
XANTENNA__4660__RESET_B net12 VGND VGND VPWR VPWR sky130_fd_sc_hd__diode_2
XFILLER_0_59_512 VPWR VGND VPWR VGND sky130_ef_sc_hd__decap_12
XFILLER_0_59_501 VGND VGND VPWR VPWR sky130_fd_sc_hd__decap_3
XTAP_TAPCELL_ROW_47_676 VGND VPWR sky130_fd_sc_hd__tapvpwrvgnd_1
XFILLER_0_52_11 VGND VGND VPWR VPWR sky130_fd_sc_hd__fill_1
X_3901_ _2016_ _1293_ VGND VGND VPWR VPWR _1303_ sky130_fd_sc_hd__and2_1
X_4881_ clknet_leaf_38_clk _0553_ net10 VGND VGND VPWR VPWR tree_instances\[20\].u_tree.pipeline_current_node\[0\]\[6\]
+ sky130_fd_sc_hd__dfrtp_1
X_3832_ _1259_ VGND VGND VPWR VPWR _0360_ sky130_fd_sc_hd__clkbuf_1
XFILLER_0_46_239 VGND VGND VPWR VPWR sky130_fd_sc_hd__fill_2
XFILLER_0_6_303 VGND VGND VPWR VPWR sky130_fd_sc_hd__fill_1
XANTENNA__3378__A1 _0925_ VGND VGND VPWR VPWR sky130_fd_sc_hd__diode_2
XFILLER_0_27_431 VPWR VGND VPWR VGND sky130_ef_sc_hd__decap_12
XTAP_TAPCELL_ROW_30_510 VGND VPWR sky130_fd_sc_hd__tapvpwrvgnd_1
XFILLER_0_27_497 VGND VGND VPWR VPWR sky130_fd_sc_hd__fill_1
X_3763_ _1223_ VGND VGND VPWR VPWR _0327_ sky130_fd_sc_hd__clkbuf_1
XFILLER_0_54_261 VGND VGND VPWR VPWR sky130_fd_sc_hd__decap_4
X_3694_ _2082_ _1179_ VGND VGND VPWR VPWR _1184_ sky130_fd_sc_hd__and2_1
X_2714_ _1606_ VGND VGND VPWR VPWR _2030_ sky130_fd_sc_hd__clkbuf_1
XFILLER_0_14_136 VGND VGND VPWR VPWR sky130_fd_sc_hd__decap_4
X_2645_ _1574_ tree_instances\[19\].u_tree.pipeline_valid\[0\] VGND VGND VPWR VPWR
+ _1969_ sky130_fd_sc_hd__or2_1
XFILLER_0_2_531 VGND VGND VPWR VPWR sky130_fd_sc_hd__fill_1
XFILLER_0_10_342 VPWR VGND VPWR VGND sky130_ef_sc_hd__decap_12
X_2576_ _1842_ _1855_ VGND VGND VPWR VPWR _1910_ sky130_fd_sc_hd__or2_1
X_4315_ _1540_ VGND VGND VPWR VPWR _0562_ sky130_fd_sc_hd__clkbuf_1
XANTENNA__3244__A _0658_ VGND VGND VPWR VPWR sky130_fd_sc_hd__diode_2
X_4246_ _1505_ VGND VGND VPWR VPWR _0528_ sky130_fd_sc_hd__clkbuf_1
XANTENNA__4748__RESET_B net10 VGND VGND VPWR VPWR sky130_fd_sc_hd__diode_2
X_4177_ _1469_ VGND VGND VPWR VPWR _0495_ sky130_fd_sc_hd__clkbuf_1
XFILLER_0_69_309 VPWR VGND VPWR VGND sky130_ef_sc_hd__decap_12
XTAP_TAPCELL_ROW_2_224 VGND VPWR sky130_fd_sc_hd__tapvpwrvgnd_1
X_3128_ tree_instances\[3\].u_tree.frame_id_out\[3\] current_voting_frame\[3\] VGND
+ VGND VPWR VPWR _0800_ sky130_fd_sc_hd__or2b_1
XFILLER_0_89_180 VGND VGND VPWR VPWR sky130_fd_sc_hd__decap_8
X_3059_ current_voting_frame\[0\] tree_instances\[17\].u_tree.frame_id_out\[0\] VGND
+ VGND VPWR VPWR _0731_ sky130_fd_sc_hd__and2b_1
XANTENNA__4330__RESET_B net9 VGND VGND VPWR VPWR sky130_fd_sc_hd__diode_2
XFILLER_0_65_526 VGND VGND VPWR VPWR sky130_fd_sc_hd__decap_6
XFILLER_0_18_475 VGND VGND VPWR VPWR sky130_fd_sc_hd__fill_1
XANTENNA__4572__SET_B net9 VGND VGND VPWR VPWR sky130_fd_sc_hd__diode_2
XFILLER_0_5_391 VGND VGND VPWR VPWR sky130_fd_sc_hd__fill_1
XFILLER_0_13_191 VGND VGND VPWR VPWR sky130_fd_sc_hd__fill_2
XANTENNA__2993__A _0665_ VGND VGND VPWR VPWR sky130_fd_sc_hd__diode_2
XANTENNA__4418__RESET_B net11 VGND VGND VPWR VPWR sky130_fd_sc_hd__diode_2
XFILLER_0_68_320 VGND VGND VPWR VPWR sky130_fd_sc_hd__fill_2
XTAP_TAPCELL_ROW_72_933 VGND VPWR sky130_fd_sc_hd__tapvpwrvgnd_1
XFILLER_0_28_206 VGND VGND VPWR VPWR sky130_fd_sc_hd__decap_6
XTAP_TAPCELL_ROW_44_646 VGND VPWR sky130_fd_sc_hd__tapvpwrvgnd_1
XFILLER_0_83_334 VGND VGND VPWR VPWR sky130_fd_sc_hd__fill_2
XFILLER_0_3_317 VPWR VGND VPWR VGND sky130_ef_sc_hd__decap_12
XFILLER_0_24_489 VPWR VGND VPWR VGND sky130_ef_sc_hd__decap_12
X_2430_ tree_instances\[16\].u_tree.pipeline_current_node\[0\]\[4\] VGND VGND VPWR
+ VPWR _1784_ sky130_fd_sc_hd__clkbuf_1
X_2361_ _1722_ _1723_ VGND VGND VPWR VPWR _1724_ sky130_fd_sc_hd__nor2_1
XANTENNA__3064__A _0660_ VGND VGND VPWR VPWR sky130_fd_sc_hd__diode_2
X_2292_ tree_instances\[8\].u_tree.pipeline_current_node\[0\]\[6\] tree_instances\[8\].u_tree.pipeline_current_node\[0\]\[7\]
+ VGND VGND VPWR VPWR _1663_ sky130_fd_sc_hd__or2_1
X_4100_ tree_instances\[16\].u_tree.pipeline_frame_id\[0\]\[4\] tree_instances\[0\].u_tree.frame_id_in\[4\]
+ _0016_ VGND VGND VPWR VPWR _1413_ sky130_fd_sc_hd__mux2_1
X_4031_ _1377_ VGND VGND VPWR VPWR _0441_ sky130_fd_sc_hd__clkbuf_1
XFILLER_0_63_32 VGND VGND VPWR VPWR sky130_fd_sc_hd__fill_1
XFILLER_0_78_139 VGND VGND VPWR VPWR sky130_fd_sc_hd__fill_1
XFILLER_0_63_65 VPWR VGND VPWR VGND sky130_ef_sc_hd__decap_12
X_4864_ clknet_leaf_35_clk _0545_ net10 VGND VGND VPWR VPWR tree_instances\[19\].u_tree.ready_for_next
+ sky130_fd_sc_hd__dfstp_1
X_4795_ clknet_leaf_40_clk _0482_ net10 VGND VGND VPWR VPWR tree_instances\[20\].u_tree.pipeline_valid\[0\]
+ sky130_fd_sc_hd__dfrtp_1
X_3815_ _1250_ VGND VGND VPWR VPWR _0352_ sky130_fd_sc_hd__clkbuf_1
X_3746_ _1206_ _1209_ VGND VGND VPWR VPWR _1215_ sky130_fd_sc_hd__and2_1
XFILLER_0_12_80 VGND VGND VPWR VPWR sky130_fd_sc_hd__decap_4
XANTENNA__3239__A _0649_ VGND VGND VPWR VPWR sky130_fd_sc_hd__diode_2
XFILLER_0_70_573 VGND VGND VPWR VPWR sky130_fd_sc_hd__fill_1
XFILLER_0_30_404 VPWR VGND VPWR VGND sky130_ef_sc_hd__decap_12
XFILLER_0_42_253 VGND VGND VPWR VPWR sky130_fd_sc_hd__decap_3
XFILLER_0_88_62 VGND VGND VPWR VPWR sky130_fd_sc_hd__fill_2
XFILLER_0_70_3 VPWR VGND VPWR VGND sky130_ef_sc_hd__decap_12
X_3677_ _1173_ VGND VGND VPWR VPWR _0291_ sky130_fd_sc_hd__clkbuf_1
X_2628_ tree_instances\[18\].u_tree.pipeline_current_node\[0\]\[8\] tree_instances\[18\].u_tree.pipeline_current_node\[0\]\[7\]
+ VGND VGND VPWR VPWR _1954_ sky130_fd_sc_hd__or2_1
X_2559_ _1895_ _1896_ VGND VGND VPWR VPWR _1897_ sky130_fd_sc_hd__nand2_1
XANTENNA__4582__RESET_B net12 VGND VGND VPWR VPWR sky130_fd_sc_hd__diode_2
X_4229_ tree_instances\[18\].u_tree.frame_id_out\[3\] tree_instances\[18\].u_tree.pipeline_frame_id\[0\]\[3\]
+ _1670_ VGND VGND VPWR VPWR _1496_ sky130_fd_sc_hd__mux2_1
XANTENNA__4511__RESET_B tree_instances\[0\].u_tree.rst_n VGND VGND VPWR VPWR sky130_fd_sc_hd__diode_2
XANTENNA__4009__S _0012_ VGND VGND VPWR VPWR sky130_fd_sc_hd__diode_2
XFILLER_0_84_109 VPWR VGND VPWR VGND sky130_ef_sc_hd__decap_12
XFILLER_0_65_312 VGND VGND VPWR VPWR sky130_fd_sc_hd__decap_4
XFILLER_0_65_345 VGND VGND VPWR VPWR sky130_fd_sc_hd__fill_1
XFILLER_0_65_334 VGND VGND VPWR VPWR sky130_fd_sc_hd__fill_2
XTAP_TAPCELL_ROW_41_616 VGND VPWR sky130_fd_sc_hd__tapvpwrvgnd_1
XFILLER_0_92_164 VGND VGND VPWR VPWR sky130_fd_sc_hd__fill_2
XFILLER_0_80_326 VPWR VGND VPWR VGND sky130_ef_sc_hd__decap_12
XFILLER_0_80_304 VGND VGND VPWR VPWR sky130_fd_sc_hd__decap_4
XFILLER_0_53_529 VGND VGND VPWR VPWR sky130_fd_sc_hd__decap_8
XFILLER_0_80_359 VGND VGND VPWR VPWR sky130_fd_sc_hd__fill_2
XFILLER_0_61_573 VGND VGND VPWR VPWR sky130_fd_sc_hd__fill_1
XANTENNA__3762__A1 _1168_ VGND VGND VPWR VPWR sky130_fd_sc_hd__diode_2
XTAP_TAPCELL_ROW_94_1147 VGND VPWR sky130_fd_sc_hd__tapvpwrvgnd_1
XANTENNA__2988__A _0664_ VGND VGND VPWR VPWR sky130_fd_sc_hd__diode_2
XFILLER_0_0_309 VPWR VGND VPWR VGND sky130_ef_sc_hd__decap_12
XTAP_TAPCELL_ROW_57_782 VGND VPWR sky130_fd_sc_hd__tapvpwrvgnd_1
XTAP_TAPCELL_ROW_29_495 VGND VPWR sky130_fd_sc_hd__tapvpwrvgnd_1
XFILLER_0_33_57 VGND VGND VPWR VPWR sky130_fd_sc_hd__decap_6
XANTENNA__3758__S _0042_ VGND VGND VPWR VPWR sky130_fd_sc_hd__diode_2
XFILLER_0_56_301 VGND VGND VPWR VPWR sky130_fd_sc_hd__fill_1
X_3600_ tree_instances\[6\].u_tree.pipeline_frame_id\[0\]\[1\] _1124_ _0036_ VGND
+ VGND VPWR VPWR _1125_ sky130_fd_sc_hd__mux2_1
X_4580_ clknet_leaf_15_clk _0300_ net12 VGND VGND VPWR VPWR tree_instances\[8\].u_tree.pipeline_current_node\[0\]\[6\]
+ sky130_fd_sc_hd__dfrtp_1
XFILLER_0_71_348 VGND VGND VPWR VPWR sky130_fd_sc_hd__fill_2
XFILLER_0_71_337 VGND VGND VPWR VPWR sky130_fd_sc_hd__decap_3
XFILLER_0_24_253 VPWR VGND VPWR VGND sky130_ef_sc_hd__decap_12
X_3531_ tree_instances\[5\].u_tree.pipeline_frame_id\[0\]\[0\] _0665_ _0034_ VGND
+ VGND VPWR VPWR _1079_ sky130_fd_sc_hd__mux2_1
XFILLER_0_12_437 VGND VGND VPWR VPWR sky130_fd_sc_hd__fill_1
XFILLER_0_12_426 VGND VGND VPWR VPWR sky130_fd_sc_hd__fill_2
XFILLER_0_12_415 VGND VGND VPWR VPWR sky130_fd_sc_hd__decap_4
XFILLER_0_52_573 VGND VGND VPWR VPWR sky130_fd_sc_hd__fill_1
XFILLER_0_12_448 VGND VGND VPWR VPWR sky130_fd_sc_hd__fill_1
X_3462_ _2105_ _1029_ VGND VGND VPWR VPWR _1035_ sky130_fd_sc_hd__and2_1
X_2413_ _1613_ tree_instances\[11\].u_tree.tree_state\[2\] VGND VGND VPWR VPWR _1769_
+ sky130_fd_sc_hd__and2b_1
X_3393_ _1891_ _0993_ _0632_ tree_instances\[2\].u_tree.ready_for_next VGND VGND VPWR
+ VPWR _0187_ sky130_fd_sc_hd__a22o_1
X_2344_ tree_instances\[6\].u_tree.pipeline_current_node\[0\]\[6\] VGND VGND VPWR
+ VPWR _1708_ sky130_fd_sc_hd__clkbuf_1
XFILLER_0_42_7 VGND VGND VPWR VPWR sky130_fd_sc_hd__fill_1
X_2275_ tree_instances\[9\].u_tree.tree_state\[2\] _1592_ tree_instances\[9\].u_tree.tree_state\[1\]
+ VGND VGND VPWR VPWR _0082_ sky130_fd_sc_hd__a21o_1
XFILLER_0_74_75 VGND VGND VPWR VPWR sky130_fd_sc_hd__fill_2
X_4014_ _1368_ VGND VGND VPWR VPWR _0433_ sky130_fd_sc_hd__clkbuf_1
XFILLER_0_74_97 VGND VGND VPWR VPWR sky130_fd_sc_hd__decap_4
XANTENNA__3241__B _0655_ VGND VGND VPWR VPWR sky130_fd_sc_hd__diode_2
XFILLER_0_94_418 VGND VGND VPWR VPWR sky130_fd_sc_hd__fill_2
XFILLER_0_90_41 VGND VGND VPWR VPWR sky130_fd_sc_hd__decap_6
XFILLER_0_59_172 VPWR VGND VPWR VGND sky130_ef_sc_hd__decap_12
XFILLER_0_59_161 VGND VGND VPWR VPWR sky130_fd_sc_hd__decap_4
XFILLER_0_90_85 VGND VGND VPWR VPWR sky130_fd_sc_hd__fill_1
XFILLER_0_47_334 VGND VGND VPWR VPWR sky130_fd_sc_hd__fill_2
X_4847_ clknet_leaf_32_clk _0528_ net10 VGND VGND VPWR VPWR tree_instances\[19\].u_tree.pipeline_current_node\[0\]\[2\]
+ sky130_fd_sc_hd__dfrtp_1
XFILLER_0_7_420 VPWR VGND VPWR VGND sky130_ef_sc_hd__decap_12
XFILLER_0_74_197 VGND VGND VPWR VPWR sky130_fd_sc_hd__fill_2
XFILLER_0_7_497 VGND VGND VPWR VPWR sky130_fd_sc_hd__decap_6
X_4778_ clknet_leaf_50_clk _0466_ net13 VGND VGND VPWR VPWR tree_instances\[16\].u_tree.pipeline_current_node\[0\]\[4\]
+ sky130_fd_sc_hd__dfrtp_1
X_3729_ _1017_ VGND VGND VPWR VPWR _1203_ sky130_fd_sc_hd__clkbuf_1
XFILLER_0_43_573 VGND VGND VPWR VPWR sky130_fd_sc_hd__fill_1
XTAP_TAPCELL_ROW_54_752 VGND VPWR sky130_fd_sc_hd__tapvpwrvgnd_1
XTAP_TAPCELL_ROW_26_465 VGND VPWR sky130_fd_sc_hd__tapvpwrvgnd_1
XFILLER_0_80_101 VGND VGND VPWR VPWR sky130_fd_sc_hd__fill_2
XFILLER_0_53_337 VPWR VGND VPWR VGND sky130_ef_sc_hd__decap_12
XFILLER_0_21_201 VGND VGND VPWR VPWR sky130_fd_sc_hd__fill_2
XFILLER_0_21_223 VGND VGND VPWR VPWR sky130_fd_sc_hd__fill_1
XFILLER_0_21_234 VGND VGND VPWR VPWR sky130_fd_sc_hd__fill_2
XANTENNA__4433__RESET_B net12 VGND VGND VPWR VPWR sky130_fd_sc_hd__diode_2
XFILLER_0_76_418 VGND VGND VPWR VPWR sky130_fd_sc_hd__fill_2
X_2962_ _0644_ VGND VGND VPWR VPWR _0020_ sky130_fd_sc_hd__inv_2
XFILLER_0_84_462 VGND VGND VPWR VPWR sky130_fd_sc_hd__fill_1
XFILLER_0_17_529 VPWR VGND VPWR VGND sky130_ef_sc_hd__decap_12
X_4701_ clknet_leaf_71_clk _0404_ net9 VGND VGND VPWR VPWR tree_instances\[13\].u_tree.pipeline_current_node\[0\]\[5\]
+ sky130_fd_sc_hd__dfrtp_1
XFILLER_0_29_367 VGND VGND VPWR VPWR sky130_fd_sc_hd__fill_2
XFILLER_0_56_164 VGND VGND VPWR VPWR sky130_fd_sc_hd__fill_2
XFILLER_0_84_484 VPWR VGND VPWR VGND sky130_ef_sc_hd__decap_12
XFILLER_0_60_88 VGND VGND VPWR VPWR sky130_fd_sc_hd__fill_1
X_4632_ clknet_leaf_3_clk _0342_ net9 VGND VGND VPWR VPWR tree_instances\[10\].u_tree.pipeline_current_node\[0\]\[7\]
+ sky130_fd_sc_hd__dfrtp_1
X_2893_ tree_instances\[20\].u_tree.prediction_valid _1908_ VGND VGND VPWR VPWR _0600_
+ sky130_fd_sc_hd__and2b_1
XFILLER_0_71_167 VGND VGND VPWR VPWR sky130_fd_sc_hd__fill_1
XFILLER_0_25_551 VGND VGND VPWR VPWR sky130_fd_sc_hd__decap_8
XFILLER_0_4_445 VPWR VGND VPWR VGND sky130_ef_sc_hd__decap_12
XFILLER_0_25_573 VGND VGND VPWR VPWR sky130_fd_sc_hd__fill_1
X_4563_ clknet_leaf_6_clk _0284_ tree_instances\[0\].u_tree.rst_n VGND VGND VPWR VPWR
+ tree_instances\[7\].u_tree.pipeline_frame_id\[0\]\[1\] sky130_fd_sc_hd__dfrtp_1
X_4494_ clknet_leaf_20_clk _0076_ net11 VGND VGND VPWR VPWR tree_instances\[6\].u_tree.tree_state\[3\]
+ sky130_fd_sc_hd__dfrtp_1
XFILLER_0_4_489 VPWR VGND VPWR VGND sky130_ef_sc_hd__decap_12
X_3514_ _1067_ VGND VGND VPWR VPWR _0234_ sky130_fd_sc_hd__clkbuf_1
XFILLER_0_12_278 VPWR VGND VPWR VGND sky130_ef_sc_hd__decap_12
X_3445_ tree_instances\[9\].u_tree.pipeline_current_node\[0\]\[4\] VGND VGND VPWR
+ VPWR _1024_ sky130_fd_sc_hd__clkbuf_1
X_3376_ tree_instances\[2\].u_tree.pipeline_frame_id\[0\]\[2\] _0675_ _0028_ VGND
+ VGND VPWR VPWR _0985_ sky130_fd_sc_hd__mux2_1
X_2327_ tree_instances\[15\].u_tree.pipeline_current_node\[0\]\[5\] tree_instances\[15\].u_tree.pipeline_current_node\[0\]\[4\]
+ VGND VGND VPWR VPWR _1693_ sky130_fd_sc_hd__or2_1
X_2258_ tree_instances\[0\].u_tree.pipeline_current_node\[0\]\[1\] _1632_ VGND VGND
+ VPWR VPWR _1633_ sky130_fd_sc_hd__nor2_1
XFILLER_0_33_3 VPWR VGND VPWR VGND sky130_ef_sc_hd__decap_12
XTAP_TAPCELL_ROW_68_888 VGND VPWR sky130_fd_sc_hd__tapvpwrvgnd_1
X_2189_ _1567_ _1571_ VGND VGND VPWR VPWR _1572_ sky130_fd_sc_hd__nand2_1
XFILLER_0_79_256 VGND VGND VPWR VPWR sky130_fd_sc_hd__fill_2
XTAP_TAPCELL_ROW_51_722 VGND VPWR sky130_fd_sc_hd__tapvpwrvgnd_1
XTAP_TAPCELL_ROW_23_435 VGND VPWR sky130_fd_sc_hd__tapvpwrvgnd_1
XFILLER_0_90_421 VGND VGND VPWR VPWR sky130_fd_sc_hd__fill_2
XFILLER_0_35_348 VGND VGND VPWR VPWR sky130_fd_sc_hd__decap_3
XFILLER_0_7_261 VPWR VGND VPWR VGND sky130_ef_sc_hd__decap_12
XFILLER_0_35_359 VGND VGND VPWR VPWR sky130_fd_sc_hd__decap_8
XFILLER_0_16_573 VGND VGND VPWR VPWR sky130_fd_sc_hd__fill_1
XTAP_TAPCELL_ROW_91_1117 VGND VPWR sky130_fd_sc_hd__tapvpwrvgnd_1
XTAP_TAPCELL_ROW_59_800 VGND VPWR sky130_fd_sc_hd__tapvpwrvgnd_1
XANTENNA__3162__A _0733_ VGND VGND VPWR VPWR sky130_fd_sc_hd__diode_2
XFILLER_0_14_15 VPWR VGND VPWR VGND sky130_ef_sc_hd__decap_12
XFILLER_0_85_237 VGND VGND VPWR VPWR sky130_fd_sc_hd__fill_2
XFILLER_0_26_337 VPWR VGND VPWR VGND sky130_ef_sc_hd__decap_12
XANTENNA__3708__A1 _1165_ VGND VGND VPWR VPWR sky130_fd_sc_hd__diode_2
XANTENNA__4685__RESET_B net12 VGND VGND VPWR VPWR sky130_fd_sc_hd__diode_2
XANTENNA__4614__RESET_B net12 VGND VGND VPWR VPWR sky130_fd_sc_hd__diode_2
X_3230_ _0765_ _0809_ _0884_ _0898_ VGND VGND VPWR VPWR _0899_ sky130_fd_sc_hd__a31o_1
XANTENNA__4549__SET_B net10 VGND VGND VPWR VPWR sky130_fd_sc_hd__diode_2
X_3161_ _0662_ _0828_ _0829_ _0830_ _0832_ VGND VGND VPWR VPWR _0833_ sky130_fd_sc_hd__a2111oi_1
XFILLER_0_55_33 VGND VGND VPWR VPWR sky130_fd_sc_hd__decap_3
X_3092_ _0759_ _0760_ _0763_ VGND VGND VPWR VPWR _0764_ sky130_fd_sc_hd__or3b_1
XFILLER_0_55_77 VGND VGND VPWR VPWR sky130_fd_sc_hd__fill_1
XFILLER_0_89_554 VGND VGND VPWR VPWR sky130_fd_sc_hd__decap_6
XTAP_TAPCELL_ROW_65_858 VGND VPWR sky130_fd_sc_hd__tapvpwrvgnd_1
XFILLER_0_76_215 VPWR VGND VPWR VGND sky130_ef_sc_hd__decap_12
XFILLER_0_71_54 VGND VGND VPWR VPWR sky130_fd_sc_hd__fill_2
XANTENNA__2416__A _1575_ VGND VGND VPWR VPWR sky130_fd_sc_hd__diode_2
X_3994_ _1358_ VGND VGND VPWR VPWR _0423_ sky130_fd_sc_hd__clkbuf_1
XFILLER_0_57_473 VGND VGND VPWR VPWR sky130_fd_sc_hd__fill_2
XFILLER_0_9_559 VGND VGND VPWR VPWR sky130_fd_sc_hd__fill_1
X_2945_ tree_instances\[20\].u_tree.tree_state\[0\] VGND VGND VPWR VPWR _0633_ sky130_fd_sc_hd__inv_2
XFILLER_0_17_337 VPWR VGND VPWR VGND sky130_ef_sc_hd__decap_12
XTAP_TAPCELL_ROW_20_405 VGND VPWR sky130_fd_sc_hd__tapvpwrvgnd_1
X_2876_ _0582_ VGND VGND VPWR VPWR _0583_ sky130_fd_sc_hd__clkbuf_1
XFILLER_0_25_370 VGND VGND VPWR VPWR sky130_fd_sc_hd__fill_2
XFILLER_0_32_307 VGND VGND VPWR VPWR sky130_fd_sc_hd__fill_1
X_4615_ clknet_leaf_6_clk _0330_ tree_instances\[0\].u_tree.rst_n VGND VGND VPWR VPWR
+ tree_instances\[9\].u_tree.frame_id_out\[2\] sky130_fd_sc_hd__dfrtp_1
XANTENNA__4355__RESET_B net13 VGND VGND VPWR VPWR sky130_fd_sc_hd__diode_2
X_4546_ clknet_leaf_57_clk _0034_ net12 VGND VGND VPWR VPWR tree_instances\[5\].u_tree.tree_state\[2\]
+ sky130_fd_sc_hd__dfrtp_1
X_4477_ clknet_leaf_65_clk _0217_ net9 VGND VGND VPWR VPWR tree_instances\[4\].u_tree.pipeline_current_node\[0\]\[7\]
+ sky130_fd_sc_hd__dfrtp_1
X_3428_ tree_instances\[3\].u_tree.frame_id_out\[1\] tree_instances\[3\].u_tree.pipeline_frame_id\[0\]\[1\]
+ _1872_ VGND VGND VPWR VPWR _1012_ sky130_fd_sc_hd__mux2_1
X_3359_ _0974_ VGND VGND VPWR VPWR _0172_ sky130_fd_sc_hd__clkbuf_1
XTAP_TAPCELL_ROW_88_1090 VGND VPWR sky130_fd_sc_hd__tapvpwrvgnd_1
XANTENNA__4017__S _1889_ VGND VGND VPWR VPWR sky130_fd_sc_hd__diode_2
XTAP_TAPCELL_ROW_0_196 VGND VPWR sky130_fd_sc_hd__tapvpwrvgnd_1
XTAP_TAPCELL_ROW_36_571 VGND VPWR sky130_fd_sc_hd__tapvpwrvgnd_1
XFILLER_0_75_281 VPWR VGND VPWR VGND sky130_ef_sc_hd__decap_12
XFILLER_0_23_329 VGND VGND VPWR VPWR sky130_fd_sc_hd__fill_2
XFILLER_0_35_178 VPWR VGND VPWR VGND sky130_ef_sc_hd__decap_12
XFILLER_0_50_159 VGND VGND VPWR VPWR sky130_fd_sc_hd__fill_1
XFILLER_0_31_384 VGND VGND VPWR VPWR sky130_fd_sc_hd__decap_8
XTAP_TAPCELL_ROW_8_285 VGND VPWR sky130_fd_sc_hd__tapvpwrvgnd_1
XFILLER_0_86_502 VGND VGND VPWR VPWR sky130_fd_sc_hd__fill_2
XFILLER_0_86_557 VPWR VGND VPWR VGND sky130_ef_sc_hd__decap_12
XTAP_TAPCELL_ROW_62_828 VGND VPWR sky130_fd_sc_hd__tapvpwrvgnd_1
XPHY_EDGE_ROW_4_Left_101 VGND VGND VPWR VPWR sky130_fd_sc_hd__decap_3
XFILLER_0_73_229 VGND VGND VPWR VPWR sky130_fd_sc_hd__fill_2
XFILLER_0_39_495 VGND VGND VPWR VPWR sky130_fd_sc_hd__decap_8
XFILLER_0_41_46 VGND VGND VPWR VPWR sky130_fd_sc_hd__decap_8
XFILLER_0_41_57 VGND VGND VPWR VPWR sky130_fd_sc_hd__fill_1
XFILLER_0_54_421 VGND VGND VPWR VPWR sky130_fd_sc_hd__fill_1
X_2730_ _2043_ VGND VGND VPWR VPWR _0104_ sky130_fd_sc_hd__clkbuf_1
XFILLER_0_26_134 VGND VGND VPWR VPWR sky130_fd_sc_hd__fill_2
X_2661_ _1977_ VGND VGND VPWR VPWR _1983_ sky130_fd_sc_hd__clkbuf_1
XFILLER_0_41_104 VGND VGND VPWR VPWR sky130_fd_sc_hd__decap_3
X_4400_ clknet_leaf_21_clk _0147_ net11 VGND VGND VPWR VPWR tree_instances\[1\].u_tree.pipeline_current_node\[0\]\[0\]
+ sky130_fd_sc_hd__dfrtp_1
XFILLER_0_41_126 VPWR VGND VPWR VGND sky130_ef_sc_hd__decap_12
X_2592_ _1923_ _1924_ VGND VGND VPWR VPWR _1925_ sky130_fd_sc_hd__nand2_1
XFILLER_0_22_340 VPWR VGND VPWR VGND sky130_ef_sc_hd__decap_12
X_4331_ clknet_leaf_0_clk _0010_ net9 VGND VGND VPWR VPWR tree_instances\[13\].u_tree.tree_state\[2\]
+ sky130_fd_sc_hd__dfrtp_1
X_4262_ _1513_ VGND VGND VPWR VPWR _0536_ sky130_fd_sc_hd__clkbuf_1
XFILLER_0_10_557 VPWR VGND VPWR VGND sky130_ef_sc_hd__decap_12
XFILLER_0_1_278 VGND VGND VPWR VPWR sky130_fd_sc_hd__fill_2
XFILLER_0_66_54 VPWR VGND VPWR VGND sky130_ef_sc_hd__decap_12
X_3213_ _0721_ _0765_ _0809_ _0884_ state\[1\] VGND VGND VPWR VPWR _0885_ sky130_fd_sc_hd__a41o_1
X_4193_ tree_instances\[18\].u_tree.tree_state\[1\] tree_instances\[18\].u_tree.tree_state\[2\]
+ _0644_ VGND VGND VPWR VPWR _1477_ sky130_fd_sc_hd__or3_1
X_3144_ _0691_ tree_instances\[9\].u_tree.frame_id_out\[3\] _0815_ VGND VGND VPWR
+ VPWR _0816_ sky130_fd_sc_hd__a21oi_1
X_3075_ _0742_ _0744_ _0746_ VGND VGND VPWR VPWR _0747_ sky130_fd_sc_hd__and3_1
XFILLER_0_89_384 VGND VGND VPWR VPWR sky130_fd_sc_hd__fill_1
XFILLER_0_49_204 VGND VGND VPWR VPWR sky130_fd_sc_hd__decap_6
XFILLER_0_82_97 VGND VGND VPWR VPWR sky130_fd_sc_hd__fill_2
XPHY_EDGE_ROW_59_Left_156 VGND VGND VPWR VPWR sky130_fd_sc_hd__decap_3
XFILLER_0_57_281 VPWR VGND VPWR VGND sky130_ef_sc_hd__decap_12
XTAP_TAPCELL_ROW_33_541 VGND VPWR sky130_fd_sc_hd__tapvpwrvgnd_1
X_3977_ _1349_ VGND VGND VPWR VPWR _0415_ sky130_fd_sc_hd__clkbuf_1
XANTENNA__4536__RESET_B net11 VGND VGND VPWR VPWR sky130_fd_sc_hd__diode_2
XFILLER_0_72_240 VGND VGND VPWR VPWR sky130_fd_sc_hd__fill_2
X_2928_ _0622_ VGND VGND VPWR VPWR _0016_ sky130_fd_sc_hd__buf_2
XFILLER_0_45_443 VGND VGND VPWR VPWR sky130_fd_sc_hd__decap_4
XTAP_TAPCELL_ROW_79_1001 VGND VPWR sky130_fd_sc_hd__tapvpwrvgnd_1
XFILLER_0_72_251 VGND VGND VPWR VPWR sky130_fd_sc_hd__fill_1
XFILLER_0_17_167 VGND VGND VPWR VPWR sky130_fd_sc_hd__fill_1
X_2859_ _2156_ VGND VGND VPWR VPWR _2161_ sky130_fd_sc_hd__clkbuf_1
XFILLER_0_72_295 VGND VGND VPWR VPWR sky130_fd_sc_hd__fill_2
XFILLER_0_60_424 VGND VGND VPWR VPWR sky130_fd_sc_hd__fill_2
XFILLER_0_5_573 VGND VGND VPWR VPWR sky130_fd_sc_hd__fill_1
X_4529_ clknet_leaf_20_clk _0259_ net11 VGND VGND VPWR VPWR tree_instances\[6\].u_tree.pipeline_current_node\[0\]\[6\]
+ sky130_fd_sc_hd__dfrtp_1
XPHY_EDGE_ROW_68_Left_165 VGND VGND VPWR VPWR sky130_fd_sc_hd__decap_3
XTAP_TAPCELL_ROW_5_255 VGND VPWR sky130_fd_sc_hd__tapvpwrvgnd_1
XANTENNA__4595__SET_B tree_instances\[0\].u_tree.rst_n VGND VGND VPWR VPWR sky130_fd_sc_hd__diode_2
XPHY_EDGE_ROW_77_Left_174 VGND VGND VPWR VPWR sky130_fd_sc_hd__decap_3
XANTENNA__3084__B2 _0655_ VGND VGND VPWR VPWR sky130_fd_sc_hd__diode_2
XANTENNA__3084__A1 _0686_ VGND VGND VPWR VPWR sky130_fd_sc_hd__diode_2
XFILLER_0_95_376 VGND VGND VPWR VPWR sky130_fd_sc_hd__decap_8
XFILLER_0_83_505 VGND VGND VPWR VPWR sky130_fd_sc_hd__fill_2
XFILLER_0_95_387 VGND VGND VPWR VPWR sky130_fd_sc_hd__decap_4
XFILLER_0_83_527 VPWR VGND VPWR VGND sky130_ef_sc_hd__decap_12
XFILLER_0_36_421 VPWR VGND VPWR VGND sky130_ef_sc_hd__decap_12
XFILLER_0_55_229 VGND VGND VPWR VPWR sky130_fd_sc_hd__decap_6
XFILLER_0_11_49 VGND VGND VPWR VPWR sky130_fd_sc_hd__decap_6
XFILLER_0_51_413 VGND VGND VPWR VPWR sky130_fd_sc_hd__fill_2
XFILLER_0_63_295 VPWR VGND VPWR VGND sky130_ef_sc_hd__decap_12
XPHY_EDGE_ROW_86_Left_183 VGND VGND VPWR VPWR sky130_fd_sc_hd__decap_3
XPHY_EDGE_ROW_95_Left_192 VGND VGND VPWR VPWR sky130_fd_sc_hd__decap_3
XFILLER_0_59_524 VPWR VGND VPWR VGND sky130_ef_sc_hd__decap_12
XTAP_TAPCELL_ROW_47_677 VGND VPWR sky130_fd_sc_hd__tapvpwrvgnd_1
X_3900_ _1302_ VGND VGND VPWR VPWR _0385_ sky130_fd_sc_hd__clkbuf_1
X_4880_ clknet_leaf_37_clk _0552_ net10 VGND VGND VPWR VPWR tree_instances\[20\].u_tree.pipeline_current_node\[0\]\[5\]
+ sky130_fd_sc_hd__dfrtp_1
Xclkbuf_leaf_71_clk clknet_3_0__leaf_clk VGND VGND VPWR VPWR clknet_leaf_71_clk sky130_fd_sc_hd__clkbuf_4
X_3831_ _2040_ _1255_ VGND VGND VPWR VPWR _1259_ sky130_fd_sc_hd__and2_1
XFILLER_0_39_270 VGND VGND VPWR VPWR sky130_fd_sc_hd__fill_2
XFILLER_0_46_218 VGND VGND VPWR VPWR sky130_fd_sc_hd__fill_1
XFILLER_0_27_443 VGND VGND VPWR VPWR sky130_fd_sc_hd__decap_4
XTAP_TAPCELL_ROW_30_511 VGND VPWR sky130_fd_sc_hd__tapvpwrvgnd_1
XFILLER_0_39_281 VGND VGND VPWR VPWR sky130_fd_sc_hd__decap_6
X_3762_ tree_instances\[9\].u_tree.pipeline_frame_id\[0\]\[4\] _1168_ _0042_ VGND
+ VGND VPWR VPWR _1223_ sky130_fd_sc_hd__mux2_1
XFILLER_0_54_251 VGND VGND VPWR VPWR sky130_fd_sc_hd__fill_1
X_3693_ _1183_ VGND VGND VPWR VPWR _0297_ sky130_fd_sc_hd__clkbuf_1
XFILLER_0_14_115 VGND VGND VPWR VPWR sky130_fd_sc_hd__decap_8
XFILLER_0_54_284 VGND VGND VPWR VPWR sky130_fd_sc_hd__fill_1
X_2713_ tree_instances\[11\].u_tree.pipeline_current_node\[0\]\[0\] VGND VGND VPWR
+ VPWR _2029_ sky130_fd_sc_hd__clkbuf_1
X_2644_ _1954_ _1960_ _1968_ tree_instances\[18\].u_tree.tree_state\[2\] VGND VGND
+ VPWR VPWR _0019_ sky130_fd_sc_hd__o31a_1
X_2575_ tree_instances\[3\].u_tree.pipeline_current_node\[0\]\[8\] VGND VGND VPWR
+ VPWR _1909_ sky130_fd_sc_hd__clkbuf_1
XFILLER_0_10_354 VGND VGND VPWR VPWR sky130_fd_sc_hd__decap_8
X_4314_ tree_instances\[20\].u_tree.frame_id_out\[1\] tree_instances\[20\].u_tree.pipeline_frame_id\[0\]\[1\]
+ _1908_ VGND VGND VPWR VPWR _1540_ sky130_fd_sc_hd__mux2_1
XFILLER_0_77_75 VGND VGND VPWR VPWR sky130_fd_sc_hd__fill_2
X_4245_ _1986_ _1502_ VGND VGND VPWR VPWR _1505_ sky130_fd_sc_hd__and2_1
X_4176_ tree_instances\[17\].u_tree.pipeline_frame_id\[0\]\[3\] _0678_ _0018_ VGND
+ VGND VPWR VPWR _1469_ sky130_fd_sc_hd__mux2_1
XTAP_TAPCELL_ROW_2_225 VGND VPWR sky130_fd_sc_hd__tapvpwrvgnd_1
X_3127_ _0658_ _0796_ _0797_ _0798_ tree_instances\[2\].u_tree.prediction_valid VGND
+ VGND VPWR VPWR _0799_ sky130_fd_sc_hd__o221a_1
XFILLER_0_93_96 VGND VGND VPWR VPWR sky130_fd_sc_hd__fill_2
X_3058_ tree_instances\[17\].u_tree.frame_id_out\[1\] VGND VGND VPWR VPWR _0730_ sky130_fd_sc_hd__inv_2
XANTENNA__3066__A1 _0647_ VGND VGND VPWR VPWR sky130_fd_sc_hd__diode_2
XANTENNA__4788__RESET_B net13 VGND VGND VPWR VPWR sky130_fd_sc_hd__diode_2
XTAP_TAPCELL_ROW_85_1060 VGND VPWR sky130_fd_sc_hd__tapvpwrvgnd_1
Xclkbuf_leaf_62_clk clknet_3_1__leaf_clk VGND VGND VPWR VPWR clknet_leaf_62_clk sky130_fd_sc_hd__clkbuf_4
XANTENNA_clkbuf_leaf_60_clk_A clknet_3_1__leaf_clk VGND VGND VPWR VPWR sky130_fd_sc_hd__diode_2
XANTENNA_output8_A net8 VGND VGND VPWR VPWR sky130_fd_sc_hd__diode_2
XFILLER_0_92_313 VGND VGND VPWR VPWR sky130_fd_sc_hd__fill_1
XTAP_TAPCELL_ROW_18_390 VGND VPWR sky130_fd_sc_hd__tapvpwrvgnd_1
XFILLER_0_92_357 VGND VGND VPWR VPWR sky130_fd_sc_hd__fill_2
XFILLER_0_18_421 VPWR VGND VPWR VGND sky130_ef_sc_hd__decap_12
XFILLER_0_5_381 VGND VGND VPWR VPWR sky130_fd_sc_hd__fill_1
XANTENNA_clkbuf_leaf_13_clk_A clknet_3_2__leaf_clk VGND VGND VPWR VPWR sky130_fd_sc_hd__diode_2
XANTENNA__3057__A1 _0658_ VGND VGND VPWR VPWR sky130_fd_sc_hd__diode_2
XANTENNA_clkbuf_leaf_28_clk_A clknet_3_6__leaf_clk VGND VGND VPWR VPWR sky130_fd_sc_hd__diode_2
XFILLER_0_68_365 VGND VGND VPWR VPWR sky130_fd_sc_hd__fill_1
XFILLER_0_68_343 VPWR VGND VPWR VGND sky130_ef_sc_hd__decap_12
Xclkbuf_leaf_53_clk clknet_3_5__leaf_clk VGND VGND VPWR VPWR clknet_leaf_53_clk sky130_fd_sc_hd__clkbuf_4
XANTENNA__4458__RESET_B net9 VGND VGND VPWR VPWR sky130_fd_sc_hd__diode_2
XTAP_TAPCELL_ROW_44_647 VGND VPWR sky130_fd_sc_hd__tapvpwrvgnd_1
XFILLER_0_83_324 VGND VGND VPWR VPWR sky130_fd_sc_hd__decap_6
XFILLER_0_83_346 VPWR VGND VPWR VGND sky130_ef_sc_hd__decap_12
XFILLER_0_22_59 VGND VGND VPWR VPWR sky130_fd_sc_hd__decap_4
XFILLER_0_36_262 VGND VGND VPWR VPWR sky130_fd_sc_hd__fill_1
XFILLER_0_24_413 VGND VGND VPWR VPWR sky130_fd_sc_hd__fill_2
XFILLER_0_24_435 VGND VGND VPWR VPWR sky130_fd_sc_hd__fill_2
XFILLER_0_3_329 VGND VGND VPWR VPWR sky130_fd_sc_hd__decap_6
XFILLER_0_24_457 VGND VGND VPWR VPWR sky130_fd_sc_hd__fill_2
XFILLER_0_51_232 VGND VGND VPWR VPWR sky130_fd_sc_hd__fill_2
X_2360_ tree_instances\[13\].u_tree.pipeline_current_node\[0\]\[0\] VGND VGND VPWR
+ VPWR _1723_ sky130_fd_sc_hd__clkbuf_1
X_2291_ _1661_ VGND VGND VPWR VPWR _1662_ sky130_fd_sc_hd__clkbuf_1
XPHY_EDGE_ROW_10_Right_10 VGND VGND VPWR VPWR sky130_fd_sc_hd__decap_3
X_4030_ _1320_ _1376_ VGND VGND VPWR VPWR _1377_ sky130_fd_sc_hd__and2_1
XANTENNA__3080__A _0726_ VGND VGND VPWR VPWR sky130_fd_sc_hd__diode_2
XANTENNA__4881__RESET_B net10 VGND VGND VPWR VPWR sky130_fd_sc_hd__diode_2
XFILLER_0_63_77 VPWR VGND VPWR VGND sky130_ef_sc_hd__decap_12
XANTENNA__4810__RESET_B net11 VGND VGND VPWR VPWR sky130_fd_sc_hd__diode_2
XFILLER_0_47_505 VPWR VGND VPWR VGND sky130_ef_sc_hd__decap_12
Xclkbuf_leaf_44_clk clknet_3_6__leaf_clk VGND VGND VPWR VPWR clknet_leaf_44_clk sky130_fd_sc_hd__clkbuf_4
XFILLER_0_86_184 VPWR VGND VPWR VGND sky130_ef_sc_hd__decap_12
XFILLER_0_19_207 VGND VGND VPWR VPWR sky130_fd_sc_hd__fill_2
X_4863_ clknet_leaf_35_clk _0544_ net10 VGND VGND VPWR VPWR tree_instances\[19\].u_tree.frame_id_out\[4\]
+ sky130_fd_sc_hd__dfrtp_1
XTAP_TAPCELL_ROW_15_360 VGND VPWR sky130_fd_sc_hd__tapvpwrvgnd_1
XFILLER_0_47_549 VGND VGND VPWR VPWR sky130_fd_sc_hd__decap_3
X_4794_ clknet_leaf_44_clk _0092_ net13 VGND VGND VPWR VPWR tree_instances\[16\].u_tree.prediction_valid
+ sky130_fd_sc_hd__dfrtp_1
X_3814_ tree_instances\[10\].u_tree.frame_id_out\[3\] tree_instances\[10\].u_tree.pipeline_frame_id\[0\]\[3\]
+ _1597_ VGND VGND VPWR VPWR _1250_ sky130_fd_sc_hd__mux2_1
X_3745_ _1214_ VGND VGND VPWR VPWR _0318_ sky130_fd_sc_hd__clkbuf_1
XFILLER_0_6_145 VGND VGND VPWR VPWR sky130_fd_sc_hd__fill_1
XFILLER_0_15_413 VGND VGND VPWR VPWR sky130_fd_sc_hd__fill_1
XFILLER_0_15_435 VGND VGND VPWR VPWR sky130_fd_sc_hd__fill_1
XFILLER_0_42_221 VGND VGND VPWR VPWR sky130_fd_sc_hd__decap_4
XFILLER_0_6_178 VPWR VGND VPWR VGND sky130_ef_sc_hd__decap_12
X_3676_ tree_instances\[7\].u_tree.frame_id_out\[3\] tree_instances\[7\].u_tree.pipeline_frame_id\[0\]\[3\]
+ tree_instances\[7\].u_tree.tree_state\[3\] VGND VGND VPWR VPWR _1173_ sky130_fd_sc_hd__mux2_1
XFILLER_0_30_416 VGND VGND VPWR VPWR sky130_fd_sc_hd__decap_4
XFILLER_0_30_427 VGND VGND VPWR VPWR sky130_fd_sc_hd__fill_1
XFILLER_0_88_85 VGND VGND VPWR VPWR sky130_fd_sc_hd__fill_1
XFILLER_0_63_3 VPWR VGND VPWR VGND sky130_ef_sc_hd__decap_12
XFILLER_0_30_449 VGND VGND VPWR VPWR sky130_fd_sc_hd__fill_2
X_2627_ tree_instances\[18\].u_tree.pipeline_current_node\[0\]\[6\] VGND VGND VPWR
+ VPWR _1953_ sky130_fd_sc_hd__clkbuf_1
X_2558_ tree_instances\[20\].u_tree.pipeline_current_node\[0\]\[8\] tree_instances\[20\].u_tree.pipeline_current_node\[0\]\[7\]
+ VGND VGND VPWR VPWR _1896_ sky130_fd_sc_hd__nor2_1
XFILLER_0_10_151 VPWR VGND VPWR VGND sky130_ef_sc_hd__decap_12
X_2489_ tree_instances\[3\].u_tree.pipeline_current_node\[0\]\[8\] VGND VGND VPWR
+ VPWR _1835_ sky130_fd_sc_hd__inv_2
XFILLER_0_10_195 VGND VGND VPWR VPWR sky130_fd_sc_hd__fill_1
X_4228_ _1495_ VGND VGND VPWR VPWR _0520_ sky130_fd_sc_hd__clkbuf_1
X_4159_ _1458_ VGND VGND VPWR VPWR _1459_ sky130_fd_sc_hd__clkbuf_1
XFILLER_0_69_129 VGND VGND VPWR VPWR sky130_fd_sc_hd__decap_8
XANTENNA__3039__A1 _0651_ VGND VGND VPWR VPWR sky130_fd_sc_hd__diode_2
XANTENNA__4551__RESET_B net13 VGND VGND VPWR VPWR sky130_fd_sc_hd__diode_2
Xclkbuf_leaf_35_clk clknet_3_7__leaf_clk VGND VGND VPWR VPWR clknet_leaf_35_clk sky130_fd_sc_hd__clkbuf_4
XFILLER_0_77_173 VGND VGND VPWR VPWR sky130_fd_sc_hd__decap_3
XFILLER_0_92_132 VGND VGND VPWR VPWR sky130_fd_sc_hd__fill_1
XTAP_TAPCELL_ROW_41_617 VGND VPWR sky130_fd_sc_hd__tapvpwrvgnd_1
XFILLER_0_80_338 VGND VGND VPWR VPWR sky130_fd_sc_hd__decap_4
XFILLER_0_73_390 VGND VGND VPWR VPWR sky130_fd_sc_hd__fill_2
XTAP_TAPCELL_ROW_94_1148 VGND VPWR sky130_fd_sc_hd__tapvpwrvgnd_1
XFILLER_0_21_449 VGND VGND VPWR VPWR sky130_fd_sc_hd__decap_8
XANTENNA__3278__A1 _0682_ VGND VGND VPWR VPWR sky130_fd_sc_hd__diode_2
XANTENNA__4639__RESET_B tree_instances\[0\].u_tree.rst_n VGND VGND VPWR VPWR sky130_fd_sc_hd__diode_2
XTAP_TAPCELL_ROW_57_783 VGND VPWR sky130_fd_sc_hd__tapvpwrvgnd_1
XTAP_TAPCELL_ROW_29_496 VGND VPWR sky130_fd_sc_hd__tapvpwrvgnd_1
XFILLER_0_29_505 VGND VGND VPWR VPWR sky130_fd_sc_hd__fill_2
Xclkbuf_leaf_26_clk clknet_3_6__leaf_clk VGND VGND VPWR VPWR clknet_leaf_26_clk sky130_fd_sc_hd__clkbuf_4
XFILLER_0_83_121 VGND VGND VPWR VPWR sky130_fd_sc_hd__decap_8
XFILLER_0_68_195 VGND VGND VPWR VPWR sky130_fd_sc_hd__fill_1
XFILLER_0_83_198 VGND VGND VPWR VPWR sky130_fd_sc_hd__decap_4
XTAP_TAPCELL_ROW_12_330 VGND VPWR sky130_fd_sc_hd__tapvpwrvgnd_1
X_3530_ _1078_ VGND VGND VPWR VPWR _0239_ sky130_fd_sc_hd__clkbuf_1
XFILLER_0_24_265 VPWR VGND VPWR VGND sky130_ef_sc_hd__decap_12
X_3461_ _1034_ VGND VGND VPWR VPWR _0214_ sky130_fd_sc_hd__clkbuf_1
X_3392_ tree_instances\[2\].u_tree.tree_state\[0\] _1890_ VGND VGND VPWR VPWR _0993_
+ sky130_fd_sc_hd__nand2_1
X_2412_ tree_instances\[5\].u_tree.tree_state\[2\] _1764_ _1765_ _1768_ tree_instances\[5\].u_tree.tree_state\[1\]
+ VGND VGND VPWR VPWR _0074_ sky130_fd_sc_hd__a41o_1
X_2343_ _1706_ VGND VGND VPWR VPWR _1707_ sky130_fd_sc_hd__clkbuf_1
XFILLER_0_58_88 VGND VGND VPWR VPWR sky130_fd_sc_hd__decap_4
XANTENNA__3269__A1 _0665_ VGND VGND VPWR VPWR sky130_fd_sc_hd__diode_2
X_4013_ tree_instances\[14\].u_tree.pipeline_frame_id\[0\]\[4\] _1168_ _0012_ VGND
+ VGND VPWR VPWR _1368_ sky130_fd_sc_hd__mux2_1
XANTENNA_clkbuf_3_6__f_clk_A clknet_0_clk VGND VGND VPWR VPWR sky130_fd_sc_hd__diode_2
XFILLER_0_35_7 VGND VGND VPWR VPWR sky130_fd_sc_hd__fill_1
X_2274_ _1647_ VGND VGND VPWR VPWR _0000_ sky130_fd_sc_hd__inv_2
XANTENNA__3241__C _0649_ VGND VGND VPWR VPWR sky130_fd_sc_hd__diode_2
Xclkbuf_leaf_17_clk clknet_3_2__leaf_clk VGND VGND VPWR VPWR clknet_leaf_17_clk sky130_fd_sc_hd__clkbuf_4
XFILLER_0_87_482 VGND VGND VPWR VPWR sky130_fd_sc_hd__decap_4
XTAP_TAPCELL_ROW_82_1030 VGND VPWR sky130_fd_sc_hd__tapvpwrvgnd_1
XFILLER_0_59_184 VPWR VGND VPWR VGND sky130_ef_sc_hd__decap_12
X_4846_ clknet_leaf_36_clk _0527_ net10 VGND VGND VPWR VPWR tree_instances\[19\].u_tree.pipeline_current_node\[0\]\[1\]
+ sky130_fd_sc_hd__dfrtp_1
XFILLER_0_7_432 VPWR VGND VPWR VGND sky130_ef_sc_hd__decap_12
XFILLER_0_15_232 VGND VGND VPWR VPWR sky130_fd_sc_hd__decap_8
X_4777_ clknet_leaf_52_clk _0465_ net13 VGND VGND VPWR VPWR tree_instances\[16\].u_tree.pipeline_current_node\[0\]\[3\]
+ sky130_fd_sc_hd__dfrtp_1
X_3728_ _1024_ VGND VGND VPWR VPWR _1202_ sky130_fd_sc_hd__clkbuf_1
XFILLER_0_15_287 VGND VGND VPWR VPWR sky130_fd_sc_hd__fill_1
X_3659_ _1163_ VGND VGND VPWR VPWR _0283_ sky130_fd_sc_hd__clkbuf_1
XFILLER_0_2_181 VGND VGND VPWR VPWR sky130_fd_sc_hd__fill_2
XFILLER_0_2_192 VGND VGND VPWR VPWR sky130_fd_sc_hd__fill_1
XFILLER_0_30_257 VGND VGND VPWR VPWR sky130_fd_sc_hd__fill_1
XANTENNA__4732__RESET_B net11 VGND VGND VPWR VPWR sky130_fd_sc_hd__diode_2
XANTENNA__3680__B2 tree_instances\[7\].u_tree.ready_for_next VGND VGND VPWR VPWR sky130_fd_sc_hd__diode_2
XFILLER_0_78_471 VGND VGND VPWR VPWR sky130_fd_sc_hd__fill_2
XTAP_TAPCELL_ROW_54_753 VGND VPWR sky130_fd_sc_hd__tapvpwrvgnd_1
XTAP_TAPCELL_ROW_26_466 VGND VPWR sky130_fd_sc_hd__tapvpwrvgnd_1
XFILLER_0_38_324 VGND VGND VPWR VPWR sky130_fd_sc_hd__fill_1
XFILLER_0_38_335 VGND VGND VPWR VPWR sky130_fd_sc_hd__fill_1
XFILLER_0_93_452 VPWR VGND VPWR VGND sky130_ef_sc_hd__decap_12
XFILLER_0_65_154 VPWR VGND VPWR VGND sky130_ef_sc_hd__decap_12
XFILLER_0_80_113 VGND VGND VPWR VPWR sky130_fd_sc_hd__fill_1
XFILLER_0_53_349 VPWR VGND VPWR VGND sky130_ef_sc_hd__decap_12
XFILLER_0_61_371 VGND VGND VPWR VPWR sky130_fd_sc_hd__fill_1
XFILLER_0_21_279 VGND VGND VPWR VPWR sky130_fd_sc_hd__fill_1
XFILLER_0_28_36 VGND VGND VPWR VPWR sky130_fd_sc_hd__decap_6
XANTENNA__4473__RESET_B tree_instances\[0\].u_tree.rst_n VGND VGND VPWR VPWR sky130_fd_sc_hd__diode_2
XANTENNA__4402__RESET_B net11 VGND VGND VPWR VPWR sky130_fd_sc_hd__diode_2
XFILLER_0_69_471 VGND VGND VPWR VPWR sky130_fd_sc_hd__fill_1
XPHY_EDGE_ROW_22_Left_119 VGND VGND VPWR VPWR sky130_fd_sc_hd__decap_3
XFILLER_0_29_335 VGND VGND VPWR VPWR sky130_fd_sc_hd__fill_1
X_2961_ _0643_ _1669_ VGND VGND VPWR VPWR _0644_ sky130_fd_sc_hd__or2_1
XFILLER_0_56_121 VGND VGND VPWR VPWR sky130_fd_sc_hd__fill_2
XFILLER_0_8_229 VGND VGND VPWR VPWR sky130_fd_sc_hd__fill_1
X_4700_ clknet_leaf_71_clk _0403_ net9 VGND VGND VPWR VPWR tree_instances\[13\].u_tree.pipeline_current_node\[0\]\[4\]
+ sky130_fd_sc_hd__dfrtp_1
XFILLER_0_84_496 VPWR VGND VPWR VGND sky130_ef_sc_hd__decap_12
XFILLER_0_60_56 VGND VGND VPWR VPWR sky130_fd_sc_hd__fill_2
X_4631_ clknet_leaf_2_clk _0341_ net9 VGND VGND VPWR VPWR tree_instances\[10\].u_tree.pipeline_current_node\[0\]\[6\]
+ sky130_fd_sc_hd__dfrtp_1
X_2892_ _0593_ VGND VGND VPWR VPWR _0599_ sky130_fd_sc_hd__clkbuf_1
XFILLER_0_71_157 VGND VGND VPWR VPWR sky130_fd_sc_hd__fill_2
XFILLER_0_37_390 VGND VGND VPWR VPWR sky130_fd_sc_hd__fill_2
XFILLER_0_4_457 VPWR VGND VPWR VGND sky130_ef_sc_hd__decap_12
X_4562_ clknet_leaf_5_clk _0283_ tree_instances\[0\].u_tree.rst_n VGND VGND VPWR VPWR
+ tree_instances\[7\].u_tree.pipeline_frame_id\[0\]\[0\] sky130_fd_sc_hd__dfrtp_1
X_4493_ clknet_leaf_20_clk _0036_ net11 VGND VGND VPWR VPWR tree_instances\[6\].u_tree.tree_state\[2\]
+ sky130_fd_sc_hd__dfrtp_1
XFILLER_0_69_65 VGND VGND VPWR VPWR sky130_fd_sc_hd__fill_1
XFILLER_0_12_213 VGND VGND VPWR VPWR sky130_fd_sc_hd__fill_1
X_3513_ _1066_ _1054_ VGND VGND VPWR VPWR _1067_ sky130_fd_sc_hd__and2_1
X_3444_ _1021_ VGND VGND VPWR VPWR _1023_ sky130_fd_sc_hd__clkbuf_1
XPHY_EDGE_ROW_31_Left_128 VGND VGND VPWR VPWR sky130_fd_sc_hd__decap_3
Xclkbuf_leaf_6_clk clknet_3_1__leaf_clk VGND VGND VPWR VPWR clknet_leaf_6_clk sky130_fd_sc_hd__clkbuf_4
X_3375_ _0984_ VGND VGND VPWR VPWR _0178_ sky130_fd_sc_hd__clkbuf_1
X_2326_ _1689_ _1690_ _1691_ VGND VGND VPWR VPWR _1692_ sky130_fd_sc_hd__or3_1
X_2257_ tree_instances\[0\].u_tree.pipeline_current_node\[0\]\[0\] VGND VGND VPWR
+ VPWR _1632_ sky130_fd_sc_hd__clkbuf_1
XTAP_TAPCELL_ROW_68_889 VGND VPWR sky130_fd_sc_hd__tapvpwrvgnd_1
XFILLER_0_26_3 VPWR VGND VPWR VGND sky130_ef_sc_hd__decap_12
X_2188_ _1569_ _1570_ VGND VGND VPWR VPWR _1571_ sky130_fd_sc_hd__nor2_1
XFILLER_0_79_235 VGND VGND VPWR VPWR sky130_fd_sc_hd__fill_1
XPHY_EDGE_ROW_40_Left_137 VGND VGND VPWR VPWR sky130_fd_sc_hd__decap_3
XFILLER_0_94_205 VGND VGND VPWR VPWR sky130_fd_sc_hd__decap_3
XFILLER_0_94_238 VGND VGND VPWR VPWR sky130_fd_sc_hd__decap_6
XFILLER_0_75_441 VGND VGND VPWR VPWR sky130_fd_sc_hd__decap_6
XTAP_TAPCELL_ROW_23_436 VGND VPWR sky130_fd_sc_hd__tapvpwrvgnd_1
XFILLER_0_35_305 VPWR VGND VPWR VGND sky130_ef_sc_hd__decap_12
XTAP_TAPCELL_ROW_51_723 VGND VPWR sky130_fd_sc_hd__tapvpwrvgnd_1
XFILLER_0_7_273 VGND VGND VPWR VPWR sky130_fd_sc_hd__decap_6
X_4829_ clknet_leaf_51_clk _0511_ net10 VGND VGND VPWR VPWR tree_instances\[18\].u_tree.pipeline_current_node\[0\]\[7\]
+ sky130_fd_sc_hd__dfrtp_1
XFILLER_0_43_371 VGND VGND VPWR VPWR sky130_fd_sc_hd__fill_2
XTAP_TAPCELL_ROW_91_1118 VGND VPWR sky130_fd_sc_hd__tapvpwrvgnd_1
XFILLER_0_11_290 VPWR VGND VPWR VGND sky130_ef_sc_hd__decap_12
XTAP_TAPCELL_ROW_59_801 VGND VPWR sky130_fd_sc_hd__tapvpwrvgnd_1
XFILLER_0_14_27 VGND VGND VPWR VPWR sky130_fd_sc_hd__fill_1
XFILLER_0_66_452 VGND VGND VPWR VPWR sky130_fd_sc_hd__fill_1
XFILLER_0_81_422 VPWR VGND VPWR VGND sky130_ef_sc_hd__decap_12
XFILLER_0_53_113 VGND VGND VPWR VPWR sky130_fd_sc_hd__decap_3
XFILLER_0_26_349 VGND VGND VPWR VPWR sky130_fd_sc_hd__decap_3
XFILLER_0_1_449 VPWR VGND VPWR VGND sky130_ef_sc_hd__decap_12
XFILLER_0_39_57 VPWR VGND VPWR VGND sky130_ef_sc_hd__decap_12
XANTENNA__4654__RESET_B tree_instances\[0\].u_tree.rst_n VGND VGND VPWR VPWR sky130_fd_sc_hd__diode_2
X_3160_ _0691_ tree_instances\[10\].u_tree.frame_id_out\[3\] tree_instances\[10\].u_tree.prediction_valid
+ _0831_ VGND VGND VPWR VPWR _0832_ sky130_fd_sc_hd__o211ai_1
Xhold1 rst_n VGND VGND VPWR VPWR net16 sky130_fd_sc_hd__dlygate4sd3_1
X_3091_ _0694_ tree_instances\[18\].u_tree.frame_id_out\[0\] _0761_ _0762_ VGND VGND
+ VPWR VPWR _0763_ sky130_fd_sc_hd__o211a_1
XFILLER_0_89_511 VGND VGND VPWR VPWR sky130_fd_sc_hd__fill_1
XTAP_TAPCELL_ROW_65_859 VGND VPWR sky130_fd_sc_hd__tapvpwrvgnd_1
XFILLER_0_76_227 VGND VGND VPWR VPWR sky130_fd_sc_hd__decap_8
XFILLER_0_9_505 VPWR VGND VPWR VGND sky130_ef_sc_hd__decap_12
XPHY_EDGE_ROW_8_Right_8 VGND VGND VPWR VPWR sky130_fd_sc_hd__decap_3
X_3993_ _1281_ _1354_ VGND VGND VPWR VPWR _1358_ sky130_fd_sc_hd__and2_1
XFILLER_0_71_99 VGND VGND VPWR VPWR sky130_fd_sc_hd__decap_3
XFILLER_0_57_441 VGND VGND VPWR VPWR sky130_fd_sc_hd__decap_4
XFILLER_0_29_143 VGND VGND VPWR VPWR sky130_fd_sc_hd__fill_1
X_2944_ _0632_ VGND VGND VPWR VPWR _0028_ sky130_fd_sc_hd__inv_2
XFILLER_0_44_113 VGND VGND VPWR VPWR sky130_fd_sc_hd__fill_1
XFILLER_0_17_349 VPWR VGND VPWR VGND sky130_ef_sc_hd__decap_12
XTAP_TAPCELL_ROW_20_406 VGND VPWR sky130_fd_sc_hd__tapvpwrvgnd_1
X_2875_ _1796_ VGND VGND VPWR VPWR _0582_ sky130_fd_sc_hd__clkbuf_1
XFILLER_0_72_477 VGND VGND VPWR VPWR sky130_fd_sc_hd__fill_2
X_4614_ clknet_leaf_7_clk _0329_ net12 VGND VGND VPWR VPWR tree_instances\[9\].u_tree.frame_id_out\[1\]
+ sky130_fd_sc_hd__dfrtp_1
XFILLER_0_4_265 VGND VGND VPWR VPWR sky130_fd_sc_hd__decap_8
X_4545_ clknet_leaf_57_clk _0033_ net12 VGND VGND VPWR VPWR tree_instances\[5\].u_tree.tree_state\[1\]
+ sky130_fd_sc_hd__dfrtp_1
XFILLER_0_40_363 VGND VGND VPWR VPWR sky130_fd_sc_hd__fill_1
XFILLER_0_96_41 VPWR VGND VPWR VGND sky130_ef_sc_hd__decap_12
X_4476_ clknet_leaf_56_clk _0216_ net9 VGND VGND VPWR VPWR tree_instances\[4\].u_tree.pipeline_current_node\[0\]\[6\]
+ sky130_fd_sc_hd__dfrtp_1
XFILLER_0_40_385 VGND VGND VPWR VPWR sky130_fd_sc_hd__decap_8
XFILLER_0_96_85 VPWR VGND VPWR VGND sky130_ef_sc_hd__decap_12
XANTENNA__4395__RESET_B net11 VGND VGND VPWR VPWR sky130_fd_sc_hd__diode_2
X_3427_ _1011_ VGND VGND VPWR VPWR _0203_ sky130_fd_sc_hd__clkbuf_1
XPHY_EDGE_ROW_39_Right_39 VGND VGND VPWR VPWR sky130_fd_sc_hd__decap_3
X_3358_ _0973_ _0960_ VGND VGND VPWR VPWR _0974_ sky130_fd_sc_hd__and2_1
X_2309_ _1676_ VGND VGND VPWR VPWR _1677_ sky130_fd_sc_hd__clkbuf_1
X_3289_ _0932_ VGND VGND VPWR VPWR _0144_ sky130_fd_sc_hd__clkbuf_1
XFILLER_0_95_503 VGND VGND VPWR VPWR sky130_fd_sc_hd__fill_1
XTAP_TAPCELL_ROW_88_1091 VGND VPWR sky130_fd_sc_hd__tapvpwrvgnd_1
XFILLER_0_67_216 VGND VGND VPWR VPWR sky130_fd_sc_hd__fill_1
XTAP_TAPCELL_ROW_0_197 VGND VPWR sky130_fd_sc_hd__tapvpwrvgnd_1
XTAP_TAPCELL_ROW_36_572 VGND VPWR sky130_fd_sc_hd__tapvpwrvgnd_1
XFILLER_0_48_430 VGND VGND VPWR VPWR sky130_fd_sc_hd__decap_3
XPHY_EDGE_ROW_48_Right_48 VGND VGND VPWR VPWR sky130_fd_sc_hd__decap_3
XFILLER_0_35_113 VGND VGND VPWR VPWR sky130_fd_sc_hd__decap_3
XFILLER_0_75_293 VPWR VGND VPWR VGND sky130_ef_sc_hd__decap_12
XFILLER_0_35_135 VPWR VGND VPWR VGND sky130_ef_sc_hd__decap_12
XFILLER_0_90_263 VPWR VGND VPWR VGND sky130_ef_sc_hd__decap_12
XFILLER_0_23_319 VGND VGND VPWR VPWR sky130_fd_sc_hd__fill_1
XPHY_EDGE_ROW_57_Right_57 VGND VGND VPWR VPWR sky130_fd_sc_hd__decap_3
XTAP_TAPCELL_ROW_8_286 VGND VPWR sky130_fd_sc_hd__tapvpwrvgnd_1
XFILLER_0_25_15 VPWR VGND VPWR VGND sky130_ef_sc_hd__decap_12
XPHY_EDGE_ROW_66_Right_66 VGND VGND VPWR VPWR sky130_fd_sc_hd__decap_3
XTAP_TAPCELL_ROW_62_829 VGND VPWR sky130_fd_sc_hd__tapvpwrvgnd_1
XFILLER_0_86_569 VGND VGND VPWR VPWR sky130_fd_sc_hd__decap_4
X_2660_ _1980_ VGND VGND VPWR VPWR _1982_ sky130_fd_sc_hd__clkbuf_1
XFILLER_0_54_477 VPWR VGND VPWR VGND sky130_ef_sc_hd__decap_12
XFILLER_0_81_285 VGND VGND VPWR VPWR sky130_fd_sc_hd__fill_1
XFILLER_0_41_138 VPWR VGND VPWR VGND sky130_ef_sc_hd__decap_12
X_2591_ tree_instances\[1\].u_tree.pipeline_current_node\[0\]\[8\] tree_instances\[1\].u_tree.pipeline_current_node\[0\]\[7\]
+ VGND VGND VPWR VPWR _1924_ sky130_fd_sc_hd__nor2_1
XPHY_EDGE_ROW_75_Right_75 VGND VGND VPWR VPWR sky130_fd_sc_hd__decap_3
XFILLER_0_1_213 VGND VGND VPWR VPWR sky130_fd_sc_hd__decap_8
XFILLER_0_22_352 VGND VGND VPWR VPWR sky130_fd_sc_hd__decap_6
XANTENNA__4835__RESET_B net10 VGND VGND VPWR VPWR sky130_fd_sc_hd__diode_2
X_4330_ clknet_leaf_0_clk _0009_ net9 VGND VGND VPWR VPWR tree_instances\[13\].u_tree.tree_state\[1\]
+ sky130_fd_sc_hd__dfrtp_1
XFILLER_0_22_396 VPWR VGND VPWR VGND sky130_ef_sc_hd__decap_12
X_4261_ tree_instances\[19\].u_tree.pipeline_frame_id\[0\]\[1\] _0672_ _0022_ VGND
+ VGND VPWR VPWR _1513_ sky130_fd_sc_hd__mux2_1
XFILLER_0_66_11 VGND VGND VPWR VPWR sky130_fd_sc_hd__fill_2
XFILLER_0_10_569 VGND VGND VPWR VPWR sky130_fd_sc_hd__decap_4
XFILLER_0_5_47 VGND VGND VPWR VPWR sky130_fd_sc_hd__fill_2
X_3212_ _0817_ _0825_ _0843_ _0883_ VGND VGND VPWR VPWR _0884_ sky130_fd_sc_hd__nor4_1
X_4192_ tree_instances\[1\].u_tree.tree_state\[0\] _1932_ _1476_ tree_instances\[1\].u_tree.pipeline_valid\[0\]
+ VGND VGND VPWR VPWR _0503_ sky130_fd_sc_hd__o22a_1
XFILLER_0_66_88 VGND VGND VPWR VPWR sky130_fd_sc_hd__fill_2
XFILLER_0_66_66 VPWR VGND VPWR VGND sky130_ef_sc_hd__decap_12
X_3143_ _0704_ tree_instances\[9\].u_tree.frame_id_out\[2\] _0813_ _0814_ _2044_ VGND
+ VGND VPWR VPWR _0815_ sky130_fd_sc_hd__a221o_1
XPHY_EDGE_ROW_84_Right_84 VGND VGND VPWR VPWR sky130_fd_sc_hd__decap_3
XTAP_TAPCELL_ROW_78_984 VGND VPWR sky130_fd_sc_hd__tapvpwrvgnd_1
X_3074_ _0714_ tree_instances\[16\].u_tree.frame_id_out\[2\] tree_instances\[16\].u_tree.frame_id_out\[3\]
+ _0691_ _0745_ VGND VGND VPWR VPWR _0746_ sky130_fd_sc_hd__a221oi_1
XFILLER_0_82_65 VGND VGND VPWR VPWR sky130_fd_sc_hd__fill_2
XFILLER_0_89_396 VGND VGND VPWR VPWR sky130_fd_sc_hd__decap_6
XFILLER_0_49_249 VGND VGND VPWR VPWR sky130_fd_sc_hd__fill_1
XFILLER_0_57_271 VGND VGND VPWR VPWR sky130_fd_sc_hd__decap_8
XFILLER_0_9_346 VGND VGND VPWR VPWR sky130_fd_sc_hd__fill_2
XTAP_TAPCELL_ROW_33_542 VGND VPWR sky130_fd_sc_hd__tapvpwrvgnd_1
X_3976_ tree_instances\[13\].u_tree.frame_id_out\[2\] tree_instances\[13\].u_tree.pipeline_frame_id\[0\]\[2\]
+ _1577_ VGND VGND VPWR VPWR _1349_ sky130_fd_sc_hd__mux2_1
X_2927_ tree_instances\[16\].u_tree.pipeline_valid\[0\] tree_instances\[16\].u_tree.tree_state\[0\]
+ net1 VGND VGND VPWR VPWR _0622_ sky130_fd_sc_hd__and3b_1
XFILLER_0_57_293 VPWR VGND VPWR VGND sky130_ef_sc_hd__decap_12
XFILLER_0_93_3 VPWR VGND VPWR VGND sky130_ef_sc_hd__decap_12
XTAP_TAPCELL_ROW_79_1002 VGND VPWR sky130_fd_sc_hd__tapvpwrvgnd_1
XFILLER_0_5_541 VPWR VGND VPWR VGND sky130_ef_sc_hd__decap_12
XFILLER_0_17_179 VGND VGND VPWR VPWR sky130_fd_sc_hd__decap_3
X_2858_ _1911_ VGND VGND VPWR VPWR _2160_ sky130_fd_sc_hd__clkbuf_1
XPHY_EDGE_ROW_93_Right_93 VGND VGND VPWR VPWR sky130_fd_sc_hd__decap_3
XANTENNA__4576__RESET_B net11 VGND VGND VPWR VPWR sky130_fd_sc_hd__diode_2
XFILLER_0_60_458 VGND VGND VPWR VPWR sky130_fd_sc_hd__decap_6
X_2789_ tree_instances\[4\].u_tree.pipeline_current_node\[0\]\[6\] VGND VGND VPWR
+ VPWR _2094_ sky130_fd_sc_hd__clkbuf_1
X_4528_ clknet_leaf_18_clk _0258_ net11 VGND VGND VPWR VPWR tree_instances\[6\].u_tree.pipeline_current_node\[0\]\[5\]
+ sky130_fd_sc_hd__dfrtp_1
XANTENNA__4505__RESET_B net13 VGND VGND VPWR VPWR sky130_fd_sc_hd__diode_2
X_4459_ clknet_leaf_62_clk _0200_ net9 VGND VGND VPWR VPWR tree_instances\[3\].u_tree.pipeline_frame_id\[0\]\[2\]
+ sky130_fd_sc_hd__dfrtp_1
XFILLER_0_40_193 VGND VGND VPWR VPWR sky130_fd_sc_hd__fill_1
XTAP_TAPCELL_ROW_5_256 VGND VPWR sky130_fd_sc_hd__tapvpwrvgnd_1
XFILLER_0_83_539 VPWR VGND VPWR VGND sky130_ef_sc_hd__decap_12
XFILLER_0_36_400 VPWR VGND VPWR VGND sky130_ef_sc_hd__decap_12
XFILLER_0_36_433 VGND VGND VPWR VPWR sky130_fd_sc_hd__decap_8
XFILLER_0_36_444 VPWR VGND VPWR VGND sky130_ef_sc_hd__decap_12
XFILLER_0_91_561 VPWR VGND VPWR VGND sky130_ef_sc_hd__decap_12
XFILLER_0_36_477 VGND VGND VPWR VPWR sky130_fd_sc_hd__fill_2
XANTENNA__3168__A _0654_ VGND VGND VPWR VPWR sky130_fd_sc_hd__diode_2
XFILLER_0_63_285 VGND VGND VPWR VPWR sky130_fd_sc_hd__fill_1
XFILLER_0_51_447 VGND VGND VPWR VPWR sky130_fd_sc_hd__fill_1
XTAP_TAPCELL_ROW_75_954 VGND VPWR sky130_fd_sc_hd__tapvpwrvgnd_1
XFILLER_0_59_536 VPWR VGND VPWR VGND sky130_ef_sc_hd__decap_12
XTAP_TAPCELL_ROW_47_678 VGND VPWR sky130_fd_sc_hd__tapvpwrvgnd_1
XFILLER_0_74_539 VGND VGND VPWR VPWR sky130_fd_sc_hd__decap_6
X_3830_ _1258_ VGND VGND VPWR VPWR _0359_ sky130_fd_sc_hd__clkbuf_1
XFILLER_0_39_260 VGND VGND VPWR VPWR sky130_fd_sc_hd__fill_2
XTAP_TAPCELL_ROW_30_512 VGND VPWR sky130_fd_sc_hd__tapvpwrvgnd_1
X_3761_ _1222_ VGND VGND VPWR VPWR _0326_ sky130_fd_sc_hd__clkbuf_1
XFILLER_0_82_550 VPWR VGND VPWR VGND sky130_ef_sc_hd__decap_12
XANTENNA__3078__A _0660_ VGND VGND VPWR VPWR sky130_fd_sc_hd__diode_2
X_2712_ tree_instances\[11\].u_tree.pipeline_current_node\[0\]\[7\] VGND VGND VPWR
+ VPWR _2028_ sky130_fd_sc_hd__clkbuf_1
X_3692_ _2085_ _1179_ VGND VGND VPWR VPWR _1183_ sky130_fd_sc_hd__and2_1
XFILLER_0_2_533 VPWR VGND VPWR VGND sky130_ef_sc_hd__decap_12
X_2643_ _1966_ _1967_ VGND VGND VPWR VPWR _1968_ sky130_fd_sc_hd__nand2_1
X_2574_ _1880_ _1887_ tree_instances\[2\].u_tree.tree_state\[2\] VGND VGND VPWR VPWR
+ _0027_ sky130_fd_sc_hd__a21boi_1
XFILLER_0_10_300 VGND VGND VPWR VPWR sky130_fd_sc_hd__fill_1
X_4313_ _1539_ VGND VGND VPWR VPWR _0561_ sky130_fd_sc_hd__clkbuf_1
X_4244_ _1504_ VGND VGND VPWR VPWR _0527_ sky130_fd_sc_hd__clkbuf_1
X_4175_ _1468_ VGND VGND VPWR VPWR _0494_ sky130_fd_sc_hd__clkbuf_1
XTAP_TAPCELL_ROW_2_226 VGND VPWR sky130_fd_sc_hd__tapvpwrvgnd_1
X_3126_ _0651_ tree_instances\[2\].u_tree.frame_id_out\[1\] VGND VGND VPWR VPWR _0798_
+ sky130_fd_sc_hd__nor2_1
XANTENNA__4263__A1 _0674_ VGND VGND VPWR VPWR sky130_fd_sc_hd__diode_2
X_3057_ _0658_ _0723_ _0724_ _0725_ _0728_ VGND VGND VPWR VPWR _0729_ sky130_fd_sc_hd__a2111oi_1
XTAP_TAPCELL_ROW_85_1061 VGND VPWR sky130_fd_sc_hd__tapvpwrvgnd_1
XTAP_TAPCELL_ROW_18_391 VGND VPWR sky130_fd_sc_hd__tapvpwrvgnd_1
XFILLER_0_18_433 VGND VGND VPWR VPWR sky130_fd_sc_hd__fill_2
XFILLER_0_73_561 VGND VGND VPWR VPWR sky130_fd_sc_hd__fill_2
XFILLER_0_18_477 VPWR VGND VPWR VGND sky130_ef_sc_hd__decap_12
X_3959_ _1340_ VGND VGND VPWR VPWR _0406_ sky130_fd_sc_hd__clkbuf_1
XANTENNA__4757__RESET_B net10 VGND VGND VPWR VPWR sky130_fd_sc_hd__diode_2
XFILLER_0_33_447 VGND VGND VPWR VPWR sky130_fd_sc_hd__fill_1
XFILLER_0_33_469 VPWR VGND VPWR VGND sky130_ef_sc_hd__decap_12
XTAP_TAPCELL_ROW_72_924 VGND VPWR sky130_fd_sc_hd__tapvpwrvgnd_1
XFILLER_0_68_355 VGND VGND VPWR VPWR sky130_fd_sc_hd__decap_6
XTAP_TAPCELL_ROW_44_648 VGND VPWR sky130_fd_sc_hd__tapvpwrvgnd_1
XFILLER_0_95_163 VGND VGND VPWR VPWR sky130_fd_sc_hd__decap_4
XFILLER_0_95_152 VGND VGND VPWR VPWR sky130_fd_sc_hd__fill_1
XFILLER_0_83_358 VPWR VGND VPWR VGND sky130_ef_sc_hd__decap_12
XFILLER_0_36_241 VGND VGND VPWR VPWR sky130_fd_sc_hd__decap_8
XANTENNA__4498__RESET_B tree_instances\[0\].u_tree.rst_n VGND VGND VPWR VPWR sky130_fd_sc_hd__diode_2
XFILLER_0_91_380 VGND VGND VPWR VPWR sky130_fd_sc_hd__decap_3
XANTENNA__4427__RESET_B tree_instances\[0\].u_tree.rst_n VGND VGND VPWR VPWR sky130_fd_sc_hd__diode_2
X_2290_ _1659_ _1660_ VGND VGND VPWR VPWR _1661_ sky130_fd_sc_hd__nor2_1
XFILLER_0_47_24 VGND VGND VPWR VPWR sky130_fd_sc_hd__fill_2
XFILLER_0_47_57 VGND VGND VPWR VPWR sky130_fd_sc_hd__decap_3
XFILLER_0_2_15 VPWR VGND VPWR VGND sky130_ef_sc_hd__decap_12
XFILLER_0_63_23 VGND VGND VPWR VPWR sky130_fd_sc_hd__decap_3
XFILLER_0_86_141 VPWR VGND VPWR VGND sky130_ef_sc_hd__decap_12
XFILLER_0_63_89 VPWR VGND VPWR VGND sky130_ef_sc_hd__decap_12
X_4862_ clknet_leaf_28_clk _0543_ net13 VGND VGND VPWR VPWR tree_instances\[19\].u_tree.frame_id_out\[3\]
+ sky130_fd_sc_hd__dfrtp_1
XFILLER_0_47_517 VPWR VGND VPWR VGND sky130_ef_sc_hd__decap_12
XTAP_TAPCELL_ROW_15_361 VGND VPWR sky130_fd_sc_hd__tapvpwrvgnd_1
X_3813_ _1249_ VGND VGND VPWR VPWR _0351_ sky130_fd_sc_hd__clkbuf_1
XANTENNA__4850__RESET_B net13 VGND VGND VPWR VPWR sky130_fd_sc_hd__diode_2
X_4793_ clknet_leaf_42_clk _0481_ net10 VGND VGND VPWR VPWR tree_instances\[16\].u_tree.ready_for_next
+ sky130_fd_sc_hd__dfstp_1
XFILLER_0_6_113 VPWR VGND VPWR VGND sky130_ef_sc_hd__decap_12
XFILLER_0_55_572 VGND VGND VPWR VPWR sky130_fd_sc_hd__fill_2
X_3744_ _1207_ _1209_ VGND VGND VPWR VPWR _1214_ sky130_fd_sc_hd__and2_1
XFILLER_0_27_274 VGND VGND VPWR VPWR sky130_fd_sc_hd__fill_2
XFILLER_0_12_93 VGND VGND VPWR VPWR sky130_fd_sc_hd__fill_1
XFILLER_0_15_447 VGND VGND VPWR VPWR sky130_fd_sc_hd__fill_1
X_3675_ _1172_ VGND VGND VPWR VPWR _0290_ sky130_fd_sc_hd__clkbuf_1
X_2626_ _1952_ VGND VGND VPWR VPWR _0021_ sky130_fd_sc_hd__clkbuf_1
XFILLER_0_2_363 VGND VGND VPWR VPWR sky130_fd_sc_hd__fill_1
X_2557_ _1894_ VGND VGND VPWR VPWR _1895_ sky130_fd_sc_hd__clkbuf_1
XFILLER_0_56_3 VGND VGND VPWR VPWR sky130_fd_sc_hd__decap_8
XFILLER_0_10_163 VPWR VGND VPWR VGND sky130_ef_sc_hd__decap_12
X_2488_ tree_instances\[4\].u_tree.tree_state\[0\] _1833_ _1834_ VGND VGND VPWR VPWR
+ _0071_ sky130_fd_sc_hd__a21o_1
X_4227_ tree_instances\[18\].u_tree.frame_id_out\[2\] tree_instances\[18\].u_tree.pipeline_frame_id\[0\]\[2\]
+ _1670_ VGND VGND VPWR VPWR _1495_ sky130_fd_sc_hd__mux2_1
X_4158_ _1457_ VGND VGND VPWR VPWR _1458_ sky130_fd_sc_hd__clkbuf_1
X_3109_ _0654_ _0777_ _0778_ _0779_ _0780_ VGND VGND VPWR VPWR _0781_ sky130_fd_sc_hd__a221o_1
X_4089_ _1407_ VGND VGND VPWR VPWR _0469_ sky130_fd_sc_hd__clkbuf_1
XFILLER_0_92_100 VGND VGND VPWR VPWR sky130_fd_sc_hd__decap_4
XANTENNA__4306__S _0026_ VGND VGND VPWR VPWR sky130_fd_sc_hd__diode_2
XFILLER_0_38_539 VGND VGND VPWR VPWR sky130_fd_sc_hd__decap_4
XTAP_TAPCELL_ROW_41_618 VGND VPWR sky130_fd_sc_hd__tapvpwrvgnd_1
XANTENNA__4591__RESET_B net12 VGND VGND VPWR VPWR sky130_fd_sc_hd__diode_2
XFILLER_0_92_177 VPWR VGND VPWR VGND sky130_ef_sc_hd__decap_12
XANTENNA__4520__RESET_B tree_instances\[0\].u_tree.rst_n VGND VGND VPWR VPWR sky130_fd_sc_hd__diode_2
XFILLER_0_61_542 VGND VGND VPWR VPWR sky130_fd_sc_hd__fill_2
XFILLER_0_33_222 VGND VGND VPWR VPWR sky130_fd_sc_hd__fill_2
XFILLER_0_5_190 VPWR VGND VPWR VGND sky130_ef_sc_hd__decap_12
XFILLER_0_21_428 VGND VGND VPWR VPWR sky130_fd_sc_hd__decap_4
XTAP_TAPCELL_ROW_94_1149 VGND VPWR sky130_fd_sc_hd__tapvpwrvgnd_1
XFILLER_0_17_27 VGND VGND VPWR VPWR sky130_fd_sc_hd__fill_2
XANTENNA__4679__RESET_B net11 VGND VGND VPWR VPWR sky130_fd_sc_hd__diode_2
XTAP_TAPCELL_ROW_29_497 VGND VPWR sky130_fd_sc_hd__tapvpwrvgnd_1
XFILLER_0_33_15 VPWR VGND VPWR VGND sky130_ef_sc_hd__decap_12
XFILLER_0_96_461 VPWR VGND VPWR VGND sky130_ef_sc_hd__decap_12
XFILLER_0_68_141 VPWR VGND VPWR VGND sky130_ef_sc_hd__decap_12
XFILLER_0_83_111 VGND VGND VPWR VPWR sky130_fd_sc_hd__fill_1
XANTENNA__4608__RESET_B net12 VGND VGND VPWR VPWR sky130_fd_sc_hd__diode_2
XFILLER_0_56_347 VGND VGND VPWR VPWR sky130_fd_sc_hd__fill_2
XFILLER_0_83_177 VGND VGND VPWR VPWR sky130_fd_sc_hd__decap_3
XTAP_TAPCELL_ROW_12_331 VGND VPWR sky130_fd_sc_hd__tapvpwrvgnd_1
XFILLER_0_24_277 VPWR VGND VPWR VGND sky130_ef_sc_hd__decap_12
X_3460_ _2101_ _1029_ VGND VGND VPWR VPWR _1034_ sky130_fd_sc_hd__and2_1
X_3391_ _0992_ VGND VGND VPWR VPWR _0186_ sky130_fd_sc_hd__clkbuf_1
X_2411_ _1767_ VGND VGND VPWR VPWR _1768_ sky130_fd_sc_hd__clkbuf_1
X_2342_ tree_instances\[6\].u_tree.pipeline_current_node\[0\]\[5\] _1705_ VGND VGND
+ VPWR VPWR _1706_ sky130_fd_sc_hd__or2_1
X_4012_ _1367_ VGND VGND VPWR VPWR _0432_ sky130_fd_sc_hd__clkbuf_1
X_2273_ _1646_ state\[0\] VGND VGND VPWR VPWR _1647_ sky130_fd_sc_hd__or2_1
XFILLER_0_79_406 VGND VGND VPWR VPWR sky130_fd_sc_hd__fill_1
XFILLER_0_59_130 VGND VGND VPWR VPWR sky130_fd_sc_hd__decap_8
XFILLER_0_90_54 VGND VGND VPWR VPWR sky130_fd_sc_hd__fill_2
XFILLER_0_87_461 VPWR VGND VPWR VGND sky130_ef_sc_hd__decap_12
XTAP_TAPCELL_ROW_82_1031 VGND VPWR sky130_fd_sc_hd__tapvpwrvgnd_1
XFILLER_0_47_303 VGND VGND VPWR VPWR sky130_fd_sc_hd__fill_2
XANTENNA__4349__RESET_B net12 VGND VGND VPWR VPWR sky130_fd_sc_hd__diode_2
XFILLER_0_59_196 VPWR VGND VPWR VGND sky130_ef_sc_hd__decap_12
XFILLER_0_47_347 VGND VGND VPWR VPWR sky130_fd_sc_hd__decap_3
X_4845_ clknet_leaf_33_clk _0526_ net10 VGND VGND VPWR VPWR tree_instances\[19\].u_tree.pipeline_current_node\[0\]\[0\]
+ sky130_fd_sc_hd__dfrtp_1
XFILLER_0_7_444 VGND VGND VPWR VPWR sky130_fd_sc_hd__decap_4
X_4776_ clknet_leaf_52_clk _0464_ net13 VGND VGND VPWR VPWR tree_instances\[16\].u_tree.pipeline_current_node\[0\]\[2\]
+ sky130_fd_sc_hd__dfrtp_1
XFILLER_0_55_380 VGND VGND VPWR VPWR sky130_fd_sc_hd__decap_8
X_3727_ _1590_ VGND VGND VPWR VPWR _1201_ sky130_fd_sc_hd__clkbuf_1
XFILLER_0_43_553 VGND VGND VPWR VPWR sky130_fd_sc_hd__decap_6
XANTENNA_clkbuf_leaf_12_clk_A clknet_3_2__leaf_clk VGND VGND VPWR VPWR sky130_fd_sc_hd__diode_2
XFILLER_0_70_361 VGND VGND VPWR VPWR sky130_fd_sc_hd__decap_3
XFILLER_0_70_350 VGND VGND VPWR VPWR sky130_fd_sc_hd__fill_2
X_3658_ tree_instances\[7\].u_tree.pipeline_frame_id\[0\]\[0\] _1162_ _0038_ VGND
+ VGND VPWR VPWR _1163_ sky130_fd_sc_hd__mux2_1
XFILLER_0_30_214 VPWR VGND VPWR VGND sky130_ef_sc_hd__decap_12
X_3589_ _1117_ VGND VGND VPWR VPWR _1118_ sky130_fd_sc_hd__clkbuf_1
X_2609_ _1937_ VGND VGND VPWR VPWR _0023_ sky130_fd_sc_hd__clkbuf_1
XANTENNA_clkbuf_leaf_27_clk_A clknet_3_6__leaf_clk VGND VGND VPWR VPWR sky130_fd_sc_hd__diode_2
XANTENNA__4772__RESET_B net10 VGND VGND VPWR VPWR sky130_fd_sc_hd__diode_2
XFILLER_0_78_483 VPWR VGND VPWR VGND sky130_ef_sc_hd__decap_12
XFILLER_0_65_111 VGND VGND VPWR VPWR sky130_fd_sc_hd__fill_1
XANTENNA__4701__RESET_B net9 VGND VGND VPWR VPWR sky130_fd_sc_hd__diode_2
XTAP_TAPCELL_ROW_26_467 VGND VPWR sky130_fd_sc_hd__tapvpwrvgnd_1
XFILLER_0_93_464 VPWR VGND VPWR VGND sky130_ef_sc_hd__decap_12
XFILLER_0_65_166 VGND VGND VPWR VPWR sky130_fd_sc_hd__fill_2
XFILLER_0_19_561 VPWR VGND VPWR VGND sky130_ef_sc_hd__decap_12
XFILLER_0_38_369 VGND VGND VPWR VPWR sky130_fd_sc_hd__decap_4
XFILLER_0_34_520 VGND VGND VPWR VPWR sky130_fd_sc_hd__decap_4
XFILLER_0_53_328 VGND VGND VPWR VPWR sky130_fd_sc_hd__fill_2
XFILLER_0_80_158 VGND VGND VPWR VPWR sky130_fd_sc_hd__decap_3
XFILLER_0_34_564 VGND VGND VPWR VPWR sky130_fd_sc_hd__decap_8
XFILLER_0_21_269 VGND VGND VPWR VPWR sky130_fd_sc_hd__fill_2
XFILLER_0_28_15 VGND VGND VPWR VPWR sky130_fd_sc_hd__decap_3
XFILLER_0_28_48 VPWR VGND VPWR VGND sky130_ef_sc_hd__decap_12
XFILLER_0_88_225 VGND VGND VPWR VPWR sky130_fd_sc_hd__decap_6
XANTENNA__3120__B2 _0714_ VGND VGND VPWR VPWR sky130_fd_sc_hd__diode_2
XANTENNA__3120__A1 _0694_ VGND VGND VPWR VPWR sky130_fd_sc_hd__diode_2
XFILLER_0_29_303 VPWR VGND VPWR VGND sky130_ef_sc_hd__decap_12
XFILLER_0_84_431 VGND VGND VPWR VPWR sky130_fd_sc_hd__decap_3
XANTENNA__4442__RESET_B net12 VGND VGND VPWR VPWR sky130_fd_sc_hd__diode_2
X_2960_ tree_instances\[18\].u_tree.tree_state\[0\] VGND VGND VPWR VPWR _0643_ sky130_fd_sc_hd__inv_2
X_2891_ _0591_ VGND VGND VPWR VPWR _0598_ sky130_fd_sc_hd__clkbuf_1
XFILLER_0_44_306 VGND VGND VPWR VPWR sky130_fd_sc_hd__fill_2
X_4630_ clknet_leaf_2_clk _0340_ net9 VGND VGND VPWR VPWR tree_instances\[10\].u_tree.pipeline_current_node\[0\]\[5\]
+ sky130_fd_sc_hd__dfrtp_1
XFILLER_0_71_169 VGND VGND VPWR VPWR sky130_fd_sc_hd__decap_8
X_4561_ clknet_leaf_67_clk _0282_ net9 VGND VGND VPWR VPWR tree_instances\[7\].u_tree.pipeline_current_node\[0\]\[8\]
+ sky130_fd_sc_hd__dfrtp_1
XANTENNA__3086__A _0661_ VGND VGND VPWR VPWR sky130_fd_sc_hd__diode_2
XFILLER_0_52_361 VGND VGND VPWR VPWR sky130_fd_sc_hd__decap_3
XFILLER_0_52_372 VPWR VGND VPWR VGND sky130_ef_sc_hd__decap_12
X_4492_ clknet_leaf_20_clk _0035_ net11 VGND VGND VPWR VPWR tree_instances\[6\].u_tree.tree_state\[1\]
+ sky130_fd_sc_hd__dfrtp_1
XFILLER_0_69_55 VGND VGND VPWR VPWR sky130_fd_sc_hd__fill_1
X_3512_ _1065_ VGND VGND VPWR VPWR _1066_ sky130_fd_sc_hd__clkbuf_1
XFILLER_0_4_469 VGND VGND VPWR VPWR sky130_fd_sc_hd__decap_6
X_3443_ _1020_ VGND VGND VPWR VPWR _1022_ sky130_fd_sc_hd__clkbuf_1
X_3374_ tree_instances\[2\].u_tree.pipeline_frame_id\[0\]\[1\] _0673_ _0028_ VGND
+ VGND VPWR VPWR _0984_ sky130_fd_sc_hd__mux2_1
XANTENNA__4793__SET_B net10 VGND VGND VPWR VPWR sky130_fd_sc_hd__diode_2
X_2325_ tree_instances\[15\].u_tree.pipeline_current_node\[0\]\[1\] tree_instances\[15\].u_tree.pipeline_current_node\[0\]\[0\]
+ VGND VGND VPWR VPWR _1691_ sky130_fd_sc_hd__or2_1
X_2256_ tree_instances\[0\].u_tree.pipeline_current_node\[0\]\[2\] VGND VGND VPWR
+ VPWR _1631_ sky130_fd_sc_hd__inv_2
XFILLER_0_79_225 VGND VGND VPWR VPWR sky130_fd_sc_hd__fill_2
X_2187_ tree_instances\[12\].u_tree.pipeline_current_node\[0\]\[6\] VGND VGND VPWR
+ VPWR _1570_ sky130_fd_sc_hd__clkbuf_1
XTAP_TAPCELL_ROW_23_437 VGND VPWR sky130_fd_sc_hd__tapvpwrvgnd_1
XFILLER_0_90_412 VGND VGND VPWR VPWR sky130_fd_sc_hd__decap_8
X_4828_ clknet_leaf_51_clk _0510_ net10 VGND VGND VPWR VPWR tree_instances\[18\].u_tree.pipeline_current_node\[0\]\[6\]
+ sky130_fd_sc_hd__dfrtp_1
XFILLER_0_35_317 VGND VGND VPWR VPWR sky130_fd_sc_hd__decap_3
XFILLER_0_47_177 VPWR VGND VPWR VGND sky130_ef_sc_hd__decap_12
XFILLER_0_90_467 VGND VGND VPWR VPWR sky130_fd_sc_hd__fill_1
XFILLER_0_90_434 VGND VGND VPWR VPWR sky130_fd_sc_hd__decap_3
XFILLER_0_50_309 VGND VGND VPWR VPWR sky130_fd_sc_hd__decap_3
X_4759_ clknet_leaf_44_clk _0456_ net11 VGND VGND VPWR VPWR tree_instances\[15\].u_tree.frame_id_out\[1\]
+ sky130_fd_sc_hd__dfrtp_1
XTAP_TAPCELL_ROW_91_1119 VGND VPWR sky130_fd_sc_hd__tapvpwrvgnd_1
XTAP_TAPCELL_ROW_59_802 VGND VPWR sky130_fd_sc_hd__tapvpwrvgnd_1
XANTENNA__3102__A1 _0662_ VGND VGND VPWR VPWR sky130_fd_sc_hd__diode_2
XFILLER_0_14_39 VGND VGND VPWR VPWR sky130_fd_sc_hd__decap_6
XFILLER_0_38_166 VGND VGND VPWR VPWR sky130_fd_sc_hd__fill_2
XFILLER_0_81_434 VPWR VGND VPWR VGND sky130_ef_sc_hd__decap_12
XANTENNA__3169__A1 _0657_ VGND VGND VPWR VPWR sky130_fd_sc_hd__diode_2
XFILLER_0_53_169 VPWR VGND VPWR VGND sky130_ef_sc_hd__decap_12
XFILLER_0_61_180 VGND VGND VPWR VPWR sky130_fd_sc_hd__fill_2
XFILLER_0_22_512 VPWR VGND VPWR VGND sky130_ef_sc_hd__decap_12
XFILLER_0_39_25 VGND VGND VPWR VPWR sky130_fd_sc_hd__fill_2
XFILLER_0_39_69 VPWR VGND VPWR VGND sky130_ef_sc_hd__decap_12
XANTENNA__4866__SET_B net13 VGND VGND VPWR VPWR sky130_fd_sc_hd__diode_2
XANTENNA__4694__RESET_B net11 VGND VGND VPWR VPWR sky130_fd_sc_hd__diode_2
X_3090_ _0685_ tree_instances\[18\].u_tree.frame_id_out\[1\] tree_instances\[18\].u_tree.prediction_valid
+ VGND VGND VPWR VPWR _0762_ sky130_fd_sc_hd__o21a_1
XFILLER_0_55_57 VGND VGND VPWR VPWR sky130_fd_sc_hd__fill_2
XANTENNA__4623__RESET_B net10 VGND VGND VPWR VPWR sky130_fd_sc_hd__diode_2
X_3992_ _1357_ VGND VGND VPWR VPWR _0422_ sky130_fd_sc_hd__clkbuf_1
XFILLER_0_9_517 VPWR VGND VPWR VGND sky130_ef_sc_hd__decap_12
XFILLER_0_29_100 VPWR VGND VPWR VGND sky130_ef_sc_hd__decap_12
XFILLER_0_71_67 VGND VGND VPWR VPWR sky130_fd_sc_hd__decap_8
X_2943_ _0631_ _1890_ VGND VGND VPWR VPWR _0632_ sky130_fd_sc_hd__or2_1
XFILLER_0_17_306 VGND VGND VPWR VPWR sky130_fd_sc_hd__fill_2
XTAP_TAPCELL_ROW_20_407 VGND VPWR sky130_fd_sc_hd__tapvpwrvgnd_1
X_2874_ tree_instances\[10\].u_tree.pipeline_current_node\[0\]\[0\] VGND VGND VPWR
+ VPWR _0581_ sky130_fd_sc_hd__clkbuf_1
XFILLER_0_44_136 VGND VGND VPWR VPWR sky130_fd_sc_hd__decap_4
XFILLER_0_32_309 VGND VGND VPWR VPWR sky130_fd_sc_hd__decap_3
X_4613_ clknet_leaf_7_clk _0328_ net12 VGND VGND VPWR VPWR tree_instances\[9\].u_tree.frame_id_out\[0\]
+ sky130_fd_sc_hd__dfrtp_1
X_4544_ clknet_leaf_57_clk _0073_ net13 VGND VGND VPWR VPWR tree_instances\[5\].u_tree.tree_state\[0\]
+ sky130_fd_sc_hd__dfstp_1
XFILLER_0_20_93 VGND VGND VPWR VPWR sky130_fd_sc_hd__decap_3
XFILLER_0_96_53 VGND VGND VPWR VPWR sky130_fd_sc_hd__decap_3
X_4475_ clknet_leaf_65_clk _0215_ tree_instances\[0\].u_tree.rst_n VGND VGND VPWR
+ VPWR tree_instances\[4\].u_tree.pipeline_current_node\[0\]\[5\] sky130_fd_sc_hd__dfrtp_1
XFILLER_0_0_461 VPWR VGND VPWR VGND sky130_ef_sc_hd__decap_12
X_3426_ tree_instances\[3\].u_tree.frame_id_out\[0\] tree_instances\[3\].u_tree.pipeline_frame_id\[0\]\[0\]
+ _1872_ VGND VGND VPWR VPWR _1011_ sky130_fd_sc_hd__mux2_1
XFILLER_0_96_97 VPWR VGND VPWR VGND sky130_ef_sc_hd__decap_12
X_3357_ _0972_ VGND VGND VPWR VPWR _0973_ sky130_fd_sc_hd__clkbuf_1
X_2308_ _1675_ tree_instances\[7\].u_tree.pipeline_current_node\[0\]\[4\] VGND VGND
+ VPWR VPWR _1676_ sky130_fd_sc_hd__or2_1
X_3288_ tree_instances\[0\].u_tree.frame_id_out\[4\] tree_instances\[0\].u_tree.pipeline_frame_id\[0\]\[4\]
+ tree_instances\[0\].u_tree.tree_state\[3\] VGND VGND VPWR VPWR _0932_ sky130_fd_sc_hd__mux2_1
X_2239_ _1614_ VGND VGND VPWR VPWR _1615_ sky130_fd_sc_hd__clkbuf_1
XANTENNA__4364__RESET_B tree_instances\[0\].u_tree.rst_n VGND VGND VPWR VPWR sky130_fd_sc_hd__diode_2
XTAP_TAPCELL_ROW_88_1092 VGND VPWR sky130_fd_sc_hd__tapvpwrvgnd_1
XFILLER_0_95_559 VGND VGND VPWR VPWR sky130_fd_sc_hd__fill_1
XTAP_TAPCELL_ROW_0_198 VGND VPWR sky130_fd_sc_hd__tapvpwrvgnd_1
XTAP_TAPCELL_ROW_36_573 VGND VPWR sky130_fd_sc_hd__tapvpwrvgnd_1
XFILLER_0_0_81 VGND VGND VPWR VPWR sky130_fd_sc_hd__decap_3
XFILLER_0_48_486 VPWR VGND VPWR VGND sky130_ef_sc_hd__decap_12
XFILLER_0_35_125 VGND VGND VPWR VPWR sky130_fd_sc_hd__decap_4
XFILLER_0_35_147 VGND VGND VPWR VPWR sky130_fd_sc_hd__decap_6
XANTENNA__4314__S _1908_ VGND VGND VPWR VPWR sky130_fd_sc_hd__diode_2
XFILLER_0_90_275 VPWR VGND VPWR VGND sky130_ef_sc_hd__decap_12
XFILLER_0_90_253 VGND VGND VPWR VPWR sky130_fd_sc_hd__decap_3
XFILLER_0_50_139 VGND VGND VPWR VPWR sky130_fd_sc_hd__fill_1
XFILLER_0_8_3 VPWR VGND VPWR VGND sky130_ef_sc_hd__decap_12
XFILLER_0_31_397 VGND VGND VPWR VPWR sky130_fd_sc_hd__fill_1
XTAP_TAPCELL_ROW_8_287 VGND VPWR sky130_fd_sc_hd__tapvpwrvgnd_1
XFILLER_0_25_27 VGND VGND VPWR VPWR sky130_fd_sc_hd__decap_8
XFILLER_0_58_206 VGND VGND VPWR VPWR sky130_fd_sc_hd__fill_2
XANTENNA_load_slew13_A tree_instances\[0\].u_tree.rst_n VGND VGND VPWR VPWR sky130_fd_sc_hd__diode_2
XFILLER_0_39_475 VGND VGND VPWR VPWR sky130_fd_sc_hd__decap_6
XFILLER_0_14_309 VGND VGND VPWR VPWR sky130_fd_sc_hd__decap_8
XFILLER_0_54_489 VPWR VGND VPWR VGND sky130_ef_sc_hd__decap_12
X_2590_ _1922_ VGND VGND VPWR VPWR _1923_ sky130_fd_sc_hd__clkbuf_1
XFILLER_0_1_225 VPWR VGND VPWR VGND sky130_ef_sc_hd__decap_12
XFILLER_0_34_180 VGND VGND VPWR VPWR sky130_fd_sc_hd__decap_8
XFILLER_0_34_191 VGND VGND VPWR VPWR sky130_fd_sc_hd__decap_4
XFILLER_0_10_504 VPWR VGND VPWR VGND sky130_ef_sc_hd__decap_12
XANTENNA__4875__RESET_B net10 VGND VGND VPWR VPWR sky130_fd_sc_hd__diode_2
X_4260_ _1512_ VGND VGND VPWR VPWR _0535_ sky130_fd_sc_hd__clkbuf_1
XFILLER_0_5_15 VPWR VGND VPWR VGND sky130_ef_sc_hd__decap_12
X_4191_ tree_instances\[1\].u_tree.tree_state\[3\] _0638_ VGND VGND VPWR VPWR _1476_
+ sky130_fd_sc_hd__nor2_1
XANTENNA__3314__A1 _0665_ VGND VGND VPWR VPWR sky130_fd_sc_hd__diode_2
X_3211_ _0852_ _0862_ _0871_ _0882_ VGND VGND VPWR VPWR _0883_ sky130_fd_sc_hd__or4_1
XFILLER_0_66_78 VGND VGND VPWR VPWR sky130_fd_sc_hd__decap_6
XANTENNA__4804__RESET_B net13 VGND VGND VPWR VPWR sky130_fd_sc_hd__diode_2
X_3142_ _0660_ tree_instances\[9\].u_tree.frame_id_out\[4\] VGND VGND VPWR VPWR _0814_
+ sky130_fd_sc_hd__or2_1
XFILLER_0_89_331 VGND VGND VPWR VPWR sky130_fd_sc_hd__decap_4
XFILLER_0_82_11 VGND VGND VPWR VPWR sky130_fd_sc_hd__fill_1
XTAP_TAPCELL_ROW_78_985 VGND VPWR sky130_fd_sc_hd__tapvpwrvgnd_1
X_3073_ _0714_ tree_instances\[16\].u_tree.frame_id_out\[2\] tree_instances\[16\].u_tree.prediction_valid
+ VGND VGND VPWR VPWR _0745_ sky130_fd_sc_hd__o21ai_1
XANTENNA__4345__D _0000_ VGND VGND VPWR VPWR sky130_fd_sc_hd__diode_2
XFILLER_0_49_239 VGND VGND VPWR VPWR sky130_fd_sc_hd__fill_2
XFILLER_0_77_559 VGND VGND VPWR VPWR sky130_fd_sc_hd__fill_1
XFILLER_0_64_209 VPWR VGND VPWR VGND sky130_ef_sc_hd__decap_12
XTAP_TAPCELL_ROW_33_543 VGND VPWR sky130_fd_sc_hd__tapvpwrvgnd_1
X_3975_ _1348_ VGND VGND VPWR VPWR _0414_ sky130_fd_sc_hd__clkbuf_1
X_2926_ _0621_ _1711_ tree_instances\[6\].u_tree.tree_state\[2\] VGND VGND VPWR VPWR
+ _0035_ sky130_fd_sc_hd__o21a_1
X_2857_ tree_instances\[1\].u_tree.pipeline_current_node\[0\]\[3\] VGND VGND VPWR
+ VPWR _2159_ sky130_fd_sc_hd__clkbuf_1
XTAP_TAPCELL_ROW_79_1003 VGND VPWR sky130_fd_sc_hd__tapvpwrvgnd_1
XFILLER_0_5_553 VGND VGND VPWR VPWR sky130_fd_sc_hd__decap_6
X_2788_ _2091_ VGND VGND VPWR VPWR _2093_ sky130_fd_sc_hd__clkbuf_1
X_4527_ clknet_leaf_20_clk _0257_ net11 VGND VGND VPWR VPWR tree_instances\[6\].u_tree.pipeline_current_node\[0\]\[4\]
+ sky130_fd_sc_hd__dfrtp_1
XFILLER_0_13_375 VPWR VGND VPWR VGND sky130_ef_sc_hd__decap_12
X_4458_ clknet_leaf_63_clk _0199_ net9 VGND VGND VPWR VPWR tree_instances\[3\].u_tree.pipeline_frame_id\[0\]\[1\]
+ sky130_fd_sc_hd__dfrtp_1
X_3409_ _1002_ VGND VGND VPWR VPWR _0194_ sky130_fd_sc_hd__clkbuf_1
X_4389_ clknet_leaf_29_clk _0137_ net13 VGND VGND VPWR VPWR tree_instances\[0\].u_tree.pipeline_frame_id\[0\]\[2\]
+ sky130_fd_sc_hd__dfrtp_1
XANTENNA__4545__RESET_B net12 VGND VGND VPWR VPWR sky130_fd_sc_hd__diode_2
XTAP_TAPCELL_ROW_5_257 VGND VPWR sky130_fd_sc_hd__tapvpwrvgnd_1
XFILLER_0_36_412 VGND VGND VPWR VPWR sky130_fd_sc_hd__decap_8
XFILLER_0_91_573 VGND VGND VPWR VPWR sky130_fd_sc_hd__fill_1
XFILLER_0_63_253 VPWR VGND VPWR VGND sky130_ef_sc_hd__decap_12
XFILLER_0_23_139 VGND VGND VPWR VPWR sky130_fd_sc_hd__fill_2
XANTENNA__3184__A _0650_ VGND VGND VPWR VPWR sky130_fd_sc_hd__diode_2
XFILLER_0_36_26 VGND VGND VPWR VPWR sky130_fd_sc_hd__fill_2
XANTENNA__2528__A _1666_ VGND VGND VPWR VPWR sky130_fd_sc_hd__diode_2
XTAP_TAPCELL_ROW_75_955 VGND VPWR sky130_fd_sc_hd__tapvpwrvgnd_1
XFILLER_0_59_548 VPWR VGND VPWR VGND sky130_ef_sc_hd__decap_12
XTAP_TAPCELL_ROW_47_679 VGND VPWR sky130_fd_sc_hd__tapvpwrvgnd_1
XFILLER_0_86_378 VGND VGND VPWR VPWR sky130_fd_sc_hd__fill_2
XFILLER_0_46_209 VGND VGND VPWR VPWR sky130_fd_sc_hd__fill_1
XFILLER_0_52_58 VGND VGND VPWR VPWR sky130_fd_sc_hd__fill_2
XTAP_TAPCELL_ROW_30_513 VGND VPWR sky130_fd_sc_hd__tapvpwrvgnd_1
X_3760_ tree_instances\[9\].u_tree.pipeline_frame_id\[0\]\[3\] _1192_ _0042_ VGND
+ VGND VPWR VPWR _1222_ sky130_fd_sc_hd__mux2_1
XFILLER_0_82_562 VPWR VGND VPWR VGND sky130_ef_sc_hd__decap_12
X_2711_ _2027_ VGND VGND VPWR VPWR _0101_ sky130_fd_sc_hd__clkbuf_1
XFILLER_0_54_253 VGND VGND VPWR VPWR sky130_fd_sc_hd__decap_4
X_3691_ _1182_ VGND VGND VPWR VPWR _0296_ sky130_fd_sc_hd__clkbuf_1
XFILLER_0_2_501 VPWR VGND VPWR VGND sky130_ef_sc_hd__decap_12
X_2642_ _1961_ _1963_ VGND VGND VPWR VPWR _1967_ sky130_fd_sc_hd__nor2_1
X_2573_ tree_instances\[20\].u_tree.tree_state\[0\] _1907_ _1908_ VGND VGND VPWR VPWR
+ _0065_ sky130_fd_sc_hd__a21o_1
XFILLER_0_2_545 VPWR VGND VPWR VGND sky130_ef_sc_hd__decap_12
XANTENNA__3535__A1 _0675_ VGND VGND VPWR VPWR sky130_fd_sc_hd__diode_2
XFILLER_0_77_55 VGND VGND VPWR VPWR sky130_fd_sc_hd__fill_1
X_4312_ tree_instances\[20\].u_tree.frame_id_out\[0\] tree_instances\[20\].u_tree.pipeline_frame_id\[0\]\[0\]
+ _1908_ VGND VGND VPWR VPWR _1539_ sky130_fd_sc_hd__mux2_1
X_4243_ _1976_ _1502_ VGND VGND VPWR VPWR _1504_ sky130_fd_sc_hd__and2_1
X_4174_ tree_instances\[17\].u_tree.pipeline_frame_id\[0\]\[2\] _0674_ _0018_ VGND
+ VGND VPWR VPWR _1468_ sky130_fd_sc_hd__mux2_1
XFILLER_0_93_54 VGND VGND VPWR VPWR sky130_fd_sc_hd__fill_2
XTAP_TAPCELL_ROW_2_227 VGND VPWR sky130_fd_sc_hd__tapvpwrvgnd_1
X_3125_ _0651_ tree_instances\[2\].u_tree.frame_id_out\[1\] VGND VGND VPWR VPWR _0797_
+ sky130_fd_sc_hd__and2_1
XFILLER_0_96_109 VGND VGND VPWR VPWR sky130_fd_sc_hd__decap_3
X_3056_ _0702_ tree_instances\[15\].u_tree.frame_id_out\[3\] tree_instances\[15\].u_tree.frame_id_out\[4\]
+ _0696_ _0727_ VGND VGND VPWR VPWR _0728_ sky130_fd_sc_hd__a221o_1
XTAP_TAPCELL_ROW_85_1062 VGND VPWR sky130_fd_sc_hd__tapvpwrvgnd_1
XFILLER_0_77_367 VPWR VGND VPWR VGND sky130_ef_sc_hd__decap_12
XFILLER_0_58_570 VGND VGND VPWR VPWR sky130_fd_sc_hd__decap_4
XFILLER_0_9_111 VGND VGND VPWR VPWR sky130_fd_sc_hd__fill_1
XTAP_TAPCELL_ROW_18_392 VGND VPWR sky130_fd_sc_hd__tapvpwrvgnd_1
XFILLER_0_37_209 VGND VGND VPWR VPWR sky130_fd_sc_hd__decap_3
XANTENNA__4419__SET_B net11 VGND VGND VPWR VPWR sky130_fd_sc_hd__diode_2
XFILLER_0_18_445 VPWR VGND VPWR VGND sky130_ef_sc_hd__decap_12
X_3958_ tree_instances\[13\].u_tree.pipeline_current_node\[0\]\[7\] _1331_ VGND VGND
+ VPWR VPWR _1340_ sky130_fd_sc_hd__and2_1
XFILLER_0_45_242 VPWR VGND VPWR VGND sky130_ef_sc_hd__decap_12
X_3889_ _2018_ _1294_ VGND VGND VPWR VPWR _1297_ sky130_fd_sc_hd__and2_1
XFILLER_0_60_201 VGND VGND VPWR VPWR sky130_fd_sc_hd__fill_1
XFILLER_0_18_489 VPWR VGND VPWR VGND sky130_ef_sc_hd__decap_12
X_2909_ _0610_ VGND VGND VPWR VPWR _0042_ sky130_fd_sc_hd__inv_2
XANTENNA__4797__RESET_B tree_instances\[0\].u_tree.rst_n VGND VGND VPWR VPWR sky130_fd_sc_hd__diode_2
XANTENNA__4726__RESET_B net10 VGND VGND VPWR VPWR sky130_fd_sc_hd__diode_2
XTAP_TAPCELL_ROW_96_1180 VGND VPWR sky130_fd_sc_hd__tapvpwrvgnd_1
XFILLER_0_68_301 VGND VGND VPWR VPWR sky130_fd_sc_hd__fill_2
XFILLER_0_95_131 VPWR VGND VPWR VGND sky130_ef_sc_hd__decap_12
XTAP_TAPCELL_ROW_72_925 VGND VPWR sky130_fd_sc_hd__tapvpwrvgnd_1
XFILLER_0_68_378 VPWR VGND VPWR VGND sky130_ef_sc_hd__decap_12
XTAP_TAPCELL_ROW_44_649 VGND VPWR sky130_fd_sc_hd__tapvpwrvgnd_1
XFILLER_0_56_507 VGND VGND VPWR VPWR sky130_fd_sc_hd__fill_2
XFILLER_0_95_186 VGND VGND VPWR VPWR sky130_fd_sc_hd__fill_2
XFILLER_0_22_39 VGND VGND VPWR VPWR sky130_fd_sc_hd__decap_6
XFILLER_0_64_573 VGND VGND VPWR VPWR sky130_fd_sc_hd__fill_1
XFILLER_0_51_289 VGND VGND VPWR VPWR sky130_fd_sc_hd__decap_3
XANTENNA__4190__A1 _1827_ VGND VGND VPWR VPWR sky130_fd_sc_hd__diode_2
XANTENNA__4190__B2 tree_instances\[17\].u_tree.ready_for_next VGND VGND VPWR VPWR
+ sky130_fd_sc_hd__diode_2
XFILLER_0_2_27 VGND VGND VPWR VPWR sky130_fd_sc_hd__fill_1
XFILLER_0_59_323 VGND VGND VPWR VPWR sky130_fd_sc_hd__fill_2
XFILLER_0_86_153 VGND VGND VPWR VPWR sky130_fd_sc_hd__fill_2
X_4861_ clknet_leaf_28_clk _0542_ net13 VGND VGND VPWR VPWR tree_instances\[19\].u_tree.frame_id_out\[2\]
+ sky130_fd_sc_hd__dfrtp_1
XFILLER_0_47_529 VPWR VGND VPWR VGND sky130_ef_sc_hd__decap_12
XFILLER_0_86_197 VPWR VGND VPWR VGND sky130_ef_sc_hd__decap_12
XTAP_TAPCELL_ROW_15_362 VGND VPWR sky130_fd_sc_hd__tapvpwrvgnd_1
X_3812_ tree_instances\[10\].u_tree.frame_id_out\[2\] tree_instances\[10\].u_tree.pipeline_frame_id\[0\]\[2\]
+ _1597_ VGND VGND VPWR VPWR _1249_ sky130_fd_sc_hd__mux2_1
XFILLER_0_6_125 VPWR VGND VPWR VGND sky130_ef_sc_hd__decap_12
XANTENNA__3756__A1 _1124_ VGND VGND VPWR VPWR sky130_fd_sc_hd__diode_2
X_4792_ clknet_leaf_42_clk _0480_ net10 VGND VGND VPWR VPWR tree_instances\[16\].u_tree.frame_id_out\[4\]
+ sky130_fd_sc_hd__dfrtp_1
XFILLER_0_12_50 VGND VGND VPWR VPWR sky130_fd_sc_hd__fill_2
X_3743_ _1213_ VGND VGND VPWR VPWR _0317_ sky130_fd_sc_hd__clkbuf_1
X_3674_ tree_instances\[7\].u_tree.frame_id_out\[2\] tree_instances\[7\].u_tree.pipeline_frame_id\[0\]\[2\]
+ tree_instances\[7\].u_tree.tree_state\[3\] VGND VGND VPWR VPWR _1172_ sky130_fd_sc_hd__mux2_1
XFILLER_0_42_245 VGND VGND VPWR VPWR sky130_fd_sc_hd__decap_6
XANTENNA__4890__RESET_B net12 VGND VGND VPWR VPWR sky130_fd_sc_hd__diode_2
X_2625_ _1951_ tree_instances\[19\].u_tree.tree_state\[2\] VGND VGND VPWR VPWR _1952_
+ sky130_fd_sc_hd__and2b_1
XFILLER_0_70_565 VGND VGND VPWR VPWR sky130_fd_sc_hd__decap_8
XFILLER_0_23_481 VPWR VGND VPWR VGND sky130_ef_sc_hd__decap_12
X_2556_ tree_instances\[20\].u_tree.pipeline_current_node\[0\]\[6\] VGND VGND VPWR
+ VPWR _1894_ sky130_fd_sc_hd__inv_2
XFILLER_0_10_175 VPWR VGND VPWR VGND sky130_ef_sc_hd__decap_12
X_2487_ tree_instances\[4\].u_tree.tree_state\[3\] VGND VGND VPWR VPWR _1834_ sky130_fd_sc_hd__buf_2
XFILLER_0_10_197 VPWR VGND VPWR VGND sky130_ef_sc_hd__decap_12
X_4226_ _1494_ VGND VGND VPWR VPWR _0519_ sky130_fd_sc_hd__clkbuf_1
X_4157_ tree_instances\[17\].u_tree.pipeline_current_node\[0\]\[5\] VGND VGND VPWR
+ VPWR _1457_ sky130_fd_sc_hd__clkbuf_1
X_3108_ tree_instances\[0\].u_tree.frame_id_out\[0\] _0646_ _0703_ tree_instances\[0\].u_tree.frame_id_out\[2\]
+ VGND VGND VPWR VPWR _0780_ sky130_fd_sc_hd__a2bb2o_1
X_4088_ _2067_ _1399_ VGND VGND VPWR VPWR _1407_ sky130_fd_sc_hd__and2_1
X_3039_ _0651_ _0707_ _0708_ _0709_ _0710_ VGND VGND VPWR VPWR _0711_ sky130_fd_sc_hd__o2111a_1
XFILLER_0_77_142 VGND VGND VPWR VPWR sky130_fd_sc_hd__decap_4
XFILLER_0_65_304 VGND VGND VPWR VPWR sky130_fd_sc_hd__fill_2
XFILLER_0_65_337 VGND VGND VPWR VPWR sky130_fd_sc_hd__fill_2
XTAP_TAPCELL_ROW_41_619 VGND VPWR sky130_fd_sc_hd__tapvpwrvgnd_1
XFILLER_0_18_253 VGND VGND VPWR VPWR sky130_fd_sc_hd__fill_2
XFILLER_0_92_189 VGND VGND VPWR VPWR sky130_fd_sc_hd__decap_6
XANTENNA__4560__RESET_B net9 VGND VGND VPWR VPWR sky130_fd_sc_hd__diode_2
XANTENNA__4172__A1 _0672_ VGND VGND VPWR VPWR sky130_fd_sc_hd__diode_2
XTAP_TAPCELL_ROW_57_774 VGND VPWR sky130_fd_sc_hd__tapvpwrvgnd_1
XFILLER_0_96_473 VGND VGND VPWR VPWR sky130_fd_sc_hd__decap_3
XFILLER_0_68_153 VGND VGND VPWR VPWR sky130_fd_sc_hd__decap_8
XTAP_TAPCELL_ROW_29_498 VGND VPWR sky130_fd_sc_hd__tapvpwrvgnd_1
XFILLER_0_33_27 VPWR VGND VPWR VGND sky130_ef_sc_hd__decap_12
XFILLER_0_56_304 VGND VGND VPWR VPWR sky130_fd_sc_hd__fill_2
XFILLER_0_56_326 VGND VGND VPWR VPWR sky130_fd_sc_hd__fill_2
XANTENNA__4648__RESET_B net9 VGND VGND VPWR VPWR sky130_fd_sc_hd__diode_2
XTAP_TAPCELL_ROW_12_332 VGND VPWR sky130_fd_sc_hd__tapvpwrvgnd_1
XFILLER_0_24_201 VGND VGND VPWR VPWR sky130_fd_sc_hd__decap_6
XFILLER_0_37_573 VGND VGND VPWR VPWR sky130_fd_sc_hd__fill_1
XFILLER_0_24_289 VPWR VGND VPWR VGND sky130_ef_sc_hd__decap_12
X_2410_ _1766_ VGND VGND VPWR VPWR _1767_ sky130_fd_sc_hd__clkbuf_1
X_3390_ tree_instances\[2\].u_tree.frame_id_out\[4\] tree_instances\[2\].u_tree.pipeline_frame_id\[0\]\[4\]
+ tree_instances\[2\].u_tree.tree_state\[3\] VGND VGND VPWR VPWR _0992_ sky130_fd_sc_hd__mux2_1
X_2341_ tree_instances\[6\].u_tree.pipeline_current_node\[0\]\[4\] VGND VGND VPWR
+ VPWR _1705_ sky130_fd_sc_hd__clkbuf_1
XFILLER_0_58_57 VGND VGND VPWR VPWR sky130_fd_sc_hd__fill_2
XFILLER_0_20_473 VGND VGND VPWR VPWR sky130_fd_sc_hd__decap_3
X_2272_ state\[1\] VGND VGND VPWR VPWR _1646_ sky130_fd_sc_hd__inv_2
X_4011_ tree_instances\[14\].u_tree.pipeline_frame_id\[0\]\[3\] _1192_ _0012_ VGND
+ VGND VPWR VPWR _1367_ sky130_fd_sc_hd__mux2_1
XFILLER_0_90_11 VGND VGND VPWR VPWR sky130_fd_sc_hd__decap_3
XFILLER_0_87_473 VGND VGND VPWR VPWR sky130_fd_sc_hd__decap_6
XTAP_TAPCELL_ROW_82_1032 VGND VPWR sky130_fd_sc_hd__tapvpwrvgnd_1
XFILLER_0_47_315 VGND VGND VPWR VPWR sky130_fd_sc_hd__fill_1
XFILLER_0_47_326 VGND VGND VPWR VPWR sky130_fd_sc_hd__decap_8
X_4844_ clknet_leaf_34_clk _0525_ net13 VGND VGND VPWR VPWR tree_instances\[19\].u_tree.pipeline_valid\[0\]
+ sky130_fd_sc_hd__dfrtp_1
XFILLER_0_62_307 VGND VGND VPWR VPWR sky130_fd_sc_hd__fill_1
XANTENNA__4389__RESET_B net13 VGND VGND VPWR VPWR sky130_fd_sc_hd__diode_2
XFILLER_0_74_167 VGND VGND VPWR VPWR sky130_fd_sc_hd__fill_1
XFILLER_0_62_329 VGND VGND VPWR VPWR sky130_fd_sc_hd__decap_4
X_4775_ clknet_leaf_52_clk _0463_ net13 VGND VGND VPWR VPWR tree_instances\[16\].u_tree.pipeline_current_node\[0\]\[1\]
+ sky130_fd_sc_hd__dfrtp_1
X_3726_ _1668_ _1200_ _0612_ tree_instances\[8\].u_tree.ready_for_next VGND VGND VPWR
+ VPWR _0313_ sky130_fd_sc_hd__a22o_1
XFILLER_0_15_223 VGND VGND VPWR VPWR sky130_fd_sc_hd__fill_1
XFILLER_0_43_521 VPWR VGND VPWR VGND sky130_ef_sc_hd__decap_12
XFILLER_0_30_226 VPWR VGND VPWR VGND sky130_ef_sc_hd__decap_12
X_3657_ _0664_ VGND VGND VPWR VPWR _1162_ sky130_fd_sc_hd__clkbuf_4
X_3588_ _1708_ VGND VGND VPWR VPWR _1117_ sky130_fd_sc_hd__clkbuf_1
X_2608_ _1926_ tree_instances\[1\].u_tree.tree_state\[2\] VGND VGND VPWR VPWR _1937_
+ sky130_fd_sc_hd__and2b_1
X_2539_ _1876_ _1879_ VGND VGND VPWR VPWR _1880_ sky130_fd_sc_hd__nor2_1
X_4209_ tree_instances\[18\].u_tree.pipeline_current_node\[0\]\[7\] _1477_ VGND VGND
+ VPWR VPWR _1486_ sky130_fd_sc_hd__and2_1
XFILLER_0_3_92 VGND VGND VPWR VPWR sky130_fd_sc_hd__fill_1
XANTENNA__3968__A1 _1192_ VGND VGND VPWR VPWR sky130_fd_sc_hd__diode_2
XTAP_TAPCELL_ROW_54_744 VGND VPWR sky130_fd_sc_hd__tapvpwrvgnd_1
XFILLER_0_78_495 VPWR VGND VPWR VGND sky130_ef_sc_hd__decap_12
XTAP_TAPCELL_ROW_26_468 VGND VPWR sky130_fd_sc_hd__tapvpwrvgnd_1
XFILLER_0_93_476 VPWR VGND VPWR VGND sky130_ef_sc_hd__decap_12
XFILLER_0_65_178 VGND VGND VPWR VPWR sky130_fd_sc_hd__fill_2
XFILLER_0_19_573 VGND VGND VPWR VPWR sky130_fd_sc_hd__fill_1
XFILLER_0_53_307 VPWR VGND VPWR VGND sky130_ef_sc_hd__decap_12
XFILLER_0_80_126 VGND VGND VPWR VPWR sky130_fd_sc_hd__fill_2
XFILLER_0_46_381 VGND VGND VPWR VPWR sky130_fd_sc_hd__fill_1
XFILLER_0_0_109 VGND VGND VPWR VPWR sky130_fd_sc_hd__decap_3
XFILLER_0_21_248 VGND VGND VPWR VPWR sky130_fd_sc_hd__fill_1
XFILLER_0_28_27 VGND VGND VPWR VPWR sky130_fd_sc_hd__fill_1
XFILLER_0_44_15 VGND VGND VPWR VPWR sky130_fd_sc_hd__decap_6
XFILLER_0_44_37 VGND VGND VPWR VPWR sky130_fd_sc_hd__fill_1
XFILLER_0_96_281 VPWR VGND VPWR VGND sky130_ef_sc_hd__decap_12
XFILLER_0_84_421 VGND VGND VPWR VPWR sky130_fd_sc_hd__decap_4
XFILLER_0_69_495 VGND VGND VPWR VPWR sky130_fd_sc_hd__decap_8
XFILLER_0_29_315 VGND VGND VPWR VPWR sky130_fd_sc_hd__decap_3
XFILLER_0_29_337 VGND VGND VPWR VPWR sky130_fd_sc_hd__decap_6
XANTENNA__4829__RESET_B net10 VGND VGND VPWR VPWR sky130_fd_sc_hd__diode_2
XFILLER_0_84_454 VGND VGND VPWR VPWR sky130_fd_sc_hd__fill_2
XFILLER_0_60_36 VGND VGND VPWR VPWR sky130_fd_sc_hd__decap_8
X_2890_ _0592_ VGND VGND VPWR VPWR _0597_ sky130_fd_sc_hd__clkbuf_1
XFILLER_0_56_156 VGND VGND VPWR VPWR sky130_fd_sc_hd__fill_2
XFILLER_0_71_104 VGND VGND VPWR VPWR sky130_fd_sc_hd__decap_4
XFILLER_0_37_370 VPWR VGND VPWR VGND sky130_ef_sc_hd__decap_12
X_4560_ clknet_leaf_66_clk _0281_ net9 VGND VGND VPWR VPWR tree_instances\[7\].u_tree.pipeline_current_node\[0\]\[7\]
+ sky130_fd_sc_hd__dfrtp_1
XANTENNA__4482__RESET_B tree_instances\[0\].u_tree.rst_n VGND VGND VPWR VPWR sky130_fd_sc_hd__diode_2
XANTENNA__4411__RESET_B net11 VGND VGND VPWR VPWR sky130_fd_sc_hd__diode_2
XFILLER_0_8_15 VPWR VGND VPWR VGND sky130_ef_sc_hd__decap_12
X_4491_ clknet_leaf_18_clk _0075_ net11 VGND VGND VPWR VPWR tree_instances\[6\].u_tree.tree_state\[0\]
+ sky130_fd_sc_hd__dfstp_1
XFILLER_0_12_226 VPWR VGND VPWR VGND sky130_ef_sc_hd__decap_12
X_3511_ _1064_ VGND VGND VPWR VPWR _1065_ sky130_fd_sc_hd__clkbuf_1
XFILLER_0_52_384 VPWR VGND VPWR VGND sky130_ef_sc_hd__decap_12
X_3442_ tree_instances\[9\].u_tree.pipeline_current_node\[0\]\[2\] VGND VGND VPWR
+ VPWR _1021_ sky130_fd_sc_hd__clkbuf_1
X_3373_ _0983_ VGND VGND VPWR VPWR _0177_ sky130_fd_sc_hd__clkbuf_1
XFILLER_0_85_11 VGND VGND VPWR VPWR sky130_fd_sc_hd__decap_3
X_2324_ tree_instances\[15\].u_tree.pipeline_current_node\[0\]\[2\] VGND VGND VPWR
+ VPWR _1690_ sky130_fd_sc_hd__clkbuf_1
X_2255_ _1629_ VGND VGND VPWR VPWR _1630_ sky130_fd_sc_hd__clkbuf_1
XFILLER_0_85_99 VPWR VGND VPWR VGND sky130_ef_sc_hd__decap_12
X_2186_ _1568_ VGND VGND VPWR VPWR _1569_ sky130_fd_sc_hd__clkbuf_1
XFILLER_0_87_281 VGND VGND VPWR VPWR sky130_fd_sc_hd__fill_2
XFILLER_0_75_410 VGND VGND VPWR VPWR sky130_fd_sc_hd__fill_1
XTAP_TAPCELL_ROW_23_438 VGND VPWR sky130_fd_sc_hd__tapvpwrvgnd_1
XTAP_TAPCELL_ROW_51_714 VGND VPWR sky130_fd_sc_hd__tapvpwrvgnd_1
X_4827_ clknet_leaf_49_clk _0509_ net10 VGND VGND VPWR VPWR tree_instances\[18\].u_tree.pipeline_current_node\[0\]\[5\]
+ sky130_fd_sc_hd__dfrtp_1
XFILLER_0_47_189 VPWR VGND VPWR VGND sky130_ef_sc_hd__decap_12
XFILLER_0_90_457 VGND VGND VPWR VPWR sky130_fd_sc_hd__fill_2
XFILLER_0_62_159 VGND VGND VPWR VPWR sky130_fd_sc_hd__decap_3
XFILLER_0_31_502 VGND VGND VPWR VPWR sky130_fd_sc_hd__fill_2
X_4758_ clknet_leaf_44_clk _0455_ net10 VGND VGND VPWR VPWR tree_instances\[15\].u_tree.frame_id_out\[0\]
+ sky130_fd_sc_hd__dfrtp_1
X_4689_ clknet_leaf_19_clk _0393_ net11 VGND VGND VPWR VPWR tree_instances\[12\].u_tree.frame_id_out\[1\]
+ sky130_fd_sc_hd__dfrtp_1
X_3709_ _1191_ VGND VGND VPWR VPWR _0305_ sky130_fd_sc_hd__clkbuf_1
XFILLER_0_31_513 VGND VGND VPWR VPWR sky130_fd_sc_hd__fill_1
XTAP_TAPCELL_ROW_59_803 VGND VPWR sky130_fd_sc_hd__tapvpwrvgnd_1
XTAP_TAPCELL_ROW_67_880 VGND VPWR sky130_fd_sc_hd__tapvpwrvgnd_1
XFILLER_0_85_207 VGND VGND VPWR VPWR sky130_fd_sc_hd__fill_1
XFILLER_0_66_421 VGND VGND VPWR VPWR sky130_fd_sc_hd__decap_3
XFILLER_0_14_29 VGND VGND VPWR VPWR sky130_fd_sc_hd__decap_3
XFILLER_0_78_292 VGND VGND VPWR VPWR sky130_fd_sc_hd__decap_8
XFILLER_0_38_145 VGND VGND VPWR VPWR sky130_fd_sc_hd__decap_4
XFILLER_0_66_498 VPWR VGND VPWR VGND sky130_ef_sc_hd__decap_12
XFILLER_0_26_307 VGND VGND VPWR VPWR sky130_fd_sc_hd__fill_1
XFILLER_0_38_178 VGND VGND VPWR VPWR sky130_fd_sc_hd__fill_1
XFILLER_0_81_446 VGND VGND VPWR VPWR sky130_fd_sc_hd__fill_2
XFILLER_0_22_502 VGND VGND VPWR VPWR sky130_fd_sc_hd__decap_4
XFILLER_0_34_351 VGND VGND VPWR VPWR sky130_fd_sc_hd__fill_2
XFILLER_0_22_524 VGND VGND VPWR VPWR sky130_fd_sc_hd__decap_8
XFILLER_0_39_15 VGND VGND VPWR VPWR sky130_fd_sc_hd__decap_6
XANTENNA_clkbuf_leaf_11_clk_A clknet_3_2__leaf_clk VGND VGND VPWR VPWR sky130_fd_sc_hd__diode_2
X_3991_ _1292_ _1354_ VGND VGND VPWR VPWR _1357_ sky130_fd_sc_hd__and2_1
XFILLER_0_69_281 VGND VGND VPWR VPWR sky130_fd_sc_hd__fill_2
XANTENNA__4663__RESET_B net12 VGND VGND VPWR VPWR sky130_fd_sc_hd__diode_2
XFILLER_0_71_79 VPWR VGND VPWR VGND sky130_ef_sc_hd__decap_12
X_2942_ tree_instances\[2\].u_tree.tree_state\[0\] VGND VGND VPWR VPWR _0631_ sky130_fd_sc_hd__inv_2
XFILLER_0_9_529 VPWR VGND VPWR VGND sky130_ef_sc_hd__decap_12
XANTENNA_clkbuf_leaf_26_clk_A clknet_3_6__leaf_clk VGND VGND VPWR VPWR sky130_fd_sc_hd__diode_2
XFILLER_0_84_262 VGND VGND VPWR VPWR sky130_fd_sc_hd__decap_8
XFILLER_0_29_167 VGND VGND VPWR VPWR sky130_fd_sc_hd__fill_1
XANTENNA__3097__A _0653_ VGND VGND VPWR VPWR sky130_fd_sc_hd__diode_2
XTAP_TAPCELL_ROW_20_408 VGND VPWR sky130_fd_sc_hd__tapvpwrvgnd_1
X_2873_ _0579_ VGND VGND VPWR VPWR _0580_ sky130_fd_sc_hd__clkbuf_1
XFILLER_0_44_126 VGND VGND VPWR VPWR sky130_fd_sc_hd__fill_1
XFILLER_0_4_223 VPWR VGND VPWR VGND sky130_ef_sc_hd__decap_12
XFILLER_0_4_201 VGND VGND VPWR VPWR sky130_fd_sc_hd__fill_2
X_4612_ clknet_leaf_6_clk _0327_ tree_instances\[0\].u_tree.rst_n VGND VGND VPWR VPWR
+ tree_instances\[9\].u_tree.pipeline_frame_id\[0\]\[4\] sky130_fd_sc_hd__dfrtp_1
X_4543_ clknet_leaf_23_clk _0102_ net11 VGND VGND VPWR VPWR tree_instances\[6\].u_tree.prediction_valid
+ sky130_fd_sc_hd__dfrtp_1
XFILLER_0_40_321 VGND VGND VPWR VPWR sky130_fd_sc_hd__fill_2
X_4474_ clknet_leaf_65_clk _0214_ tree_instances\[0\].u_tree.rst_n VGND VGND VPWR
+ VPWR tree_instances\[4\].u_tree.pipeline_current_node\[0\]\[4\] sky130_fd_sc_hd__dfrtp_1
XFILLER_0_0_473 VGND VGND VPWR VPWR sky130_fd_sc_hd__decap_3
X_3425_ _1010_ VGND VGND VPWR VPWR _0202_ sky130_fd_sc_hd__clkbuf_1
X_3356_ tree_instances\[2\].u_tree.pipeline_current_node\[0\]\[4\] VGND VGND VPWR
+ VPWR _0972_ sky130_fd_sc_hd__clkbuf_1
X_3287_ _0931_ VGND VGND VPWR VPWR _0143_ sky130_fd_sc_hd__clkbuf_1
X_2307_ tree_instances\[7\].u_tree.pipeline_current_node\[0\]\[3\] VGND VGND VPWR
+ VPWR _1675_ sky130_fd_sc_hd__clkbuf_1
X_2238_ tree_instances\[17\].u_tree.pipeline_current_node\[0\]\[5\] tree_instances\[17\].u_tree.pipeline_current_node\[0\]\[4\]
+ VGND VGND VPWR VPWR _1614_ sky130_fd_sc_hd__nor2_1
XFILLER_0_31_3 VGND VGND VPWR VPWR sky130_fd_sc_hd__decap_6
XFILLER_0_95_505 VPWR VGND VPWR VGND sky130_ef_sc_hd__decap_12
XTAP_TAPCELL_ROW_88_1093 VGND VPWR sky130_fd_sc_hd__tapvpwrvgnd_1
X_2169_ tree_instances\[15\].u_tree.ready_for_next tree_instances\[14\].u_tree.ready_for_next
+ tree_instances\[17\].u_tree.ready_for_next tree_instances\[16\].u_tree.ready_for_next
+ VGND VGND VPWR VPWR _1553_ sky130_fd_sc_hd__and4_1
XTAP_TAPCELL_ROW_64_850 VGND VPWR sky130_fd_sc_hd__tapvpwrvgnd_1
XTAP_TAPCELL_ROW_0_199 VGND VPWR sky130_fd_sc_hd__tapvpwrvgnd_1
XFILLER_0_63_402 VPWR VGND VPWR VGND sky130_ef_sc_hd__decap_12
XFILLER_0_35_104 VGND VGND VPWR VPWR sky130_fd_sc_hd__fill_2
XFILLER_0_63_446 VGND VGND VPWR VPWR sky130_fd_sc_hd__fill_2
XFILLER_0_8_573 VGND VGND VPWR VPWR sky130_fd_sc_hd__fill_1
XFILLER_0_48_498 VGND VGND VPWR VPWR sky130_fd_sc_hd__decap_6
XFILLER_0_16_340 VGND VGND VPWR VPWR sky130_fd_sc_hd__fill_2
XFILLER_0_90_287 VGND VGND VPWR VPWR sky130_fd_sc_hd__decap_4
XFILLER_0_31_310 VGND VGND VPWR VPWR sky130_fd_sc_hd__decap_6
XTAP_TAPCELL_ROW_8_288 VGND VPWR sky130_fd_sc_hd__tapvpwrvgnd_1
XANTENNA__3087__B2 _0658_ VGND VGND VPWR VPWR sky130_fd_sc_hd__diode_2
XANTENNA__3087__A1 _0685_ VGND VGND VPWR VPWR sky130_fd_sc_hd__diode_2
XFILLER_0_39_443 VGND VGND VPWR VPWR sky130_fd_sc_hd__decap_4
XFILLER_0_66_251 VGND VGND VPWR VPWR sky130_fd_sc_hd__fill_1
XFILLER_0_66_284 VGND VGND VPWR VPWR sky130_fd_sc_hd__fill_2
XFILLER_0_54_446 VGND VGND VPWR VPWR sky130_fd_sc_hd__fill_2
XFILLER_0_1_204 VGND VGND VPWR VPWR sky130_fd_sc_hd__fill_2
XFILLER_0_10_516 VPWR VGND VPWR VGND sky130_ef_sc_hd__decap_12
XFILLER_0_1_237 VGND VGND VPWR VPWR sky130_fd_sc_hd__decap_3
XFILLER_0_22_365 VGND VGND VPWR VPWR sky130_fd_sc_hd__decap_3
XFILLER_0_5_27 VPWR VGND VPWR VGND sky130_ef_sc_hd__decap_12
X_4190_ _1827_ _0934_ _0604_ tree_instances\[17\].u_tree.ready_for_next VGND VGND
+ VPWR VPWR _0502_ sky130_fd_sc_hd__a22o_1
X_3210_ _0875_ _0878_ _0881_ VGND VGND VPWR VPWR _0882_ sky130_fd_sc_hd__and3_1
X_3141_ _0661_ tree_instances\[9\].u_tree.frame_id_out\[4\] VGND VGND VPWR VPWR _0813_
+ sky130_fd_sc_hd__nand2_1
XPHY_EDGE_ROW_19_Left_116 VGND VGND VPWR VPWR sky130_fd_sc_hd__decap_3
XFILLER_0_82_23 VGND VGND VPWR VPWR sky130_fd_sc_hd__fill_2
XANTENNA__4844__RESET_B net13 VGND VGND VPWR VPWR sky130_fd_sc_hd__diode_2
XTAP_TAPCELL_ROW_78_986 VGND VPWR sky130_fd_sc_hd__tapvpwrvgnd_1
X_3072_ _0685_ tree_instances\[16\].u_tree.frame_id_out\[1\] tree_instances\[16\].u_tree.frame_id_out\[4\]
+ _0697_ _0743_ VGND VGND VPWR VPWR _0744_ sky130_fd_sc_hd__o221a_1
XFILLER_0_77_505 VPWR VGND VPWR VGND sky130_ef_sc_hd__decap_12
XANTENNA__3089__A1_N _0646_ VGND VGND VPWR VPWR sky130_fd_sc_hd__diode_2
XFILLER_0_49_229 VGND VGND VPWR VPWR sky130_fd_sc_hd__fill_2
XTAP_TAPCELL_ROW_61_820 VGND VPWR sky130_fd_sc_hd__tapvpwrvgnd_1
XFILLER_0_92_519 VPWR VGND VPWR VGND sky130_ef_sc_hd__decap_12
XFILLER_0_9_359 VPWR VGND VPWR VGND sky130_ef_sc_hd__decap_12
XFILLER_0_9_337 VGND VGND VPWR VPWR sky130_fd_sc_hd__decap_4
XFILLER_0_15_94 VGND VGND VPWR VPWR sky130_fd_sc_hd__fill_2
X_3974_ tree_instances\[13\].u_tree.frame_id_out\[1\] tree_instances\[13\].u_tree.pipeline_frame_id\[0\]\[1\]
+ _1577_ VGND VGND VPWR VPWR _1348_ sky130_fd_sc_hd__mux2_1
X_2925_ _1700_ _1703_ VGND VGND VPWR VPWR _0621_ sky130_fd_sc_hd__or2_1
XFILLER_0_72_232 VGND VGND VPWR VPWR sky130_fd_sc_hd__decap_6
X_2856_ _1912_ VGND VGND VPWR VPWR _2158_ sky130_fd_sc_hd__clkbuf_1
XPHY_EDGE_ROW_28_Left_125 VGND VGND VPWR VPWR sky130_fd_sc_hd__decap_3
XFILLER_0_13_343 VGND VGND VPWR VPWR sky130_fd_sc_hd__fill_2
X_2787_ _1816_ VGND VGND VPWR VPWR _2092_ sky130_fd_sc_hd__clkbuf_1
XFILLER_0_25_181 VGND VGND VPWR VPWR sky130_fd_sc_hd__decap_3
X_4526_ clknet_leaf_18_clk _0256_ net11 VGND VGND VPWR VPWR tree_instances\[6\].u_tree.pipeline_current_node\[0\]\[3\]
+ sky130_fd_sc_hd__dfrtp_1
XFILLER_0_13_387 VGND VGND VPWR VPWR sky130_fd_sc_hd__decap_4
X_4457_ clknet_leaf_63_clk _0198_ net9 VGND VGND VPWR VPWR tree_instances\[3\].u_tree.pipeline_frame_id\[0\]\[0\]
+ sky130_fd_sc_hd__dfrtp_1
XFILLER_0_0_281 VPWR VGND VPWR VGND sky130_ef_sc_hd__decap_12
X_3408_ _2109_ _0996_ VGND VGND VPWR VPWR _1002_ sky130_fd_sc_hd__and2_1
X_4388_ clknet_leaf_30_clk _0136_ net11 VGND VGND VPWR VPWR tree_instances\[0\].u_tree.pipeline_frame_id\[0\]\[1\]
+ sky130_fd_sc_hd__dfrtp_1
XPHY_EDGE_ROW_37_Left_134 VGND VGND VPWR VPWR sky130_fd_sc_hd__decap_3
X_3339_ tree_instances\[2\].u_tree.tree_state\[1\] tree_instances\[2\].u_tree.tree_state\[2\]
+ _0632_ VGND VGND VPWR VPWR _0959_ sky130_fd_sc_hd__or3_1
XTAP_TAPCELL_ROW_5_258 VGND VPWR sky130_fd_sc_hd__tapvpwrvgnd_1
XANTENNA__4585__RESET_B net11 VGND VGND VPWR VPWR sky130_fd_sc_hd__diode_2
XANTENNA__3069__B2 _0685_ VGND VGND VPWR VPWR sky130_fd_sc_hd__diode_2
Xclkbuf_leaf_65_clk clknet_3_1__leaf_clk VGND VGND VPWR VPWR clknet_leaf_65_clk sky130_fd_sc_hd__clkbuf_4
XANTENNA__4514__RESET_B net13 VGND VGND VPWR VPWR sky130_fd_sc_hd__diode_2
XFILLER_0_48_251 VGND VGND VPWR VPWR sky130_fd_sc_hd__fill_1
XFILLER_0_63_221 VGND VGND VPWR VPWR sky130_fd_sc_hd__decap_3
XPHY_EDGE_ROW_46_Left_143 VGND VGND VPWR VPWR sky130_fd_sc_hd__decap_3
XFILLER_0_63_265 VPWR VGND VPWR VGND sky130_ef_sc_hd__decap_12
XFILLER_0_51_449 VPWR VGND VPWR VGND sky130_ef_sc_hd__decap_12
XPHY_EDGE_ROW_55_Left_152 VGND VGND VPWR VPWR sky130_fd_sc_hd__decap_3
XTAP_TAPCELL_ROW_75_956 VGND VPWR sky130_fd_sc_hd__tapvpwrvgnd_1
XFILLER_0_59_505 VGND VGND VPWR VPWR sky130_fd_sc_hd__decap_4
Xclkbuf_leaf_56_clk clknet_3_4__leaf_clk VGND VGND VPWR VPWR clknet_leaf_56_clk sky130_fd_sc_hd__clkbuf_4
XFILLER_0_86_302 VGND VGND VPWR VPWR sky130_fd_sc_hd__decap_6
XFILLER_0_52_15 VPWR VGND VPWR VGND sky130_ef_sc_hd__decap_12
XPHY_EDGE_ROW_64_Left_161 VGND VGND VPWR VPWR sky130_fd_sc_hd__decap_3
XFILLER_0_39_240 VPWR VGND VPWR VGND sky130_ef_sc_hd__decap_12
XFILLER_0_82_530 VGND VGND VPWR VPWR sky130_fd_sc_hd__fill_2
XFILLER_0_6_307 VGND VGND VPWR VPWR sky130_fd_sc_hd__fill_1
XFILLER_0_27_424 VGND VGND VPWR VPWR sky130_fd_sc_hd__fill_1
XFILLER_0_54_221 VGND VGND VPWR VPWR sky130_fd_sc_hd__decap_6
X_2710_ tree_instances\[5\].u_tree.prediction_valid _1770_ VGND VGND VPWR VPWR _2027_
+ sky130_fd_sc_hd__and2b_1
X_3690_ _2079_ _1179_ VGND VGND VPWR VPWR _1182_ sky130_fd_sc_hd__and2_1
XFILLER_0_54_276 VGND VGND VPWR VPWR sky130_fd_sc_hd__decap_8
XFILLER_0_2_513 VPWR VGND VPWR VGND sky130_ef_sc_hd__decap_12
X_2641_ tree_instances\[18\].u_tree.pipeline_current_node\[0\]\[6\] VGND VGND VPWR
+ VPWR _1966_ sky130_fd_sc_hd__inv_2
XFILLER_0_35_490 VGND VGND VPWR VPWR sky130_fd_sc_hd__decap_8
X_2572_ tree_instances\[20\].u_tree.tree_state\[3\] VGND VGND VPWR VPWR _1908_ sky130_fd_sc_hd__buf_2
XFILLER_0_2_557 VPWR VGND VPWR VGND sky130_ef_sc_hd__decap_12
XPHY_EDGE_ROW_73_Left_170 VGND VGND VPWR VPWR sky130_fd_sc_hd__decap_3
X_4311_ _1538_ VGND VGND VPWR VPWR _0560_ sky130_fd_sc_hd__clkbuf_1
X_4242_ _1503_ VGND VGND VPWR VPWR _0526_ sky130_fd_sc_hd__clkbuf_1
XFILLER_0_77_67 VGND VGND VPWR VPWR sky130_fd_sc_hd__decap_8
X_4173_ _1467_ VGND VGND VPWR VPWR _0493_ sky130_fd_sc_hd__clkbuf_1
XTAP_TAPCELL_ROW_2_228 VGND VPWR sky130_fd_sc_hd__tapvpwrvgnd_1
X_3124_ tree_instances\[2\].u_tree.frame_id_out\[3\] VGND VGND VPWR VPWR _0796_ sky130_fd_sc_hd__inv_2
XFILLER_0_89_140 VGND VGND VPWR VPWR sky130_fd_sc_hd__fill_2
X_3055_ _0726_ tree_instances\[15\].u_tree.frame_id_out\[0\] VGND VGND VPWR VPWR _0727_
+ sky130_fd_sc_hd__xor2_1
Xclkbuf_leaf_47_clk clknet_3_5__leaf_clk VGND VGND VPWR VPWR clknet_leaf_47_clk sky130_fd_sc_hd__clkbuf_4
XTAP_TAPCELL_ROW_85_1063 VGND VPWR sky130_fd_sc_hd__tapvpwrvgnd_1
XFILLER_0_77_335 VGND VGND VPWR VPWR sky130_fd_sc_hd__fill_1
XFILLER_0_77_379 VPWR VGND VPWR VGND sky130_ef_sc_hd__decap_12
XFILLER_0_9_101 VGND VGND VPWR VPWR sky130_fd_sc_hd__decap_8
XTAP_TAPCELL_ROW_18_393 VGND VPWR sky130_fd_sc_hd__tapvpwrvgnd_1
XFILLER_0_9_156 VPWR VGND VPWR VGND sky130_ef_sc_hd__decap_12
X_3957_ _1339_ VGND VGND VPWR VPWR _0405_ sky130_fd_sc_hd__clkbuf_1
X_2908_ _0609_ _1648_ VGND VGND VPWR VPWR _0610_ sky130_fd_sc_hd__or2_2
XFILLER_0_18_457 VPWR VGND VPWR VGND sky130_ef_sc_hd__decap_12
XFILLER_0_42_92 VGND VGND VPWR VPWR sky130_fd_sc_hd__fill_2
XFILLER_0_45_254 VPWR VGND VPWR VGND sky130_ef_sc_hd__decap_12
X_3888_ _1296_ VGND VGND VPWR VPWR _0379_ sky130_fd_sc_hd__clkbuf_1
XFILLER_0_5_340 VGND VGND VPWR VPWR sky130_fd_sc_hd__fill_1
X_2839_ _2141_ VGND VGND VPWR VPWR _2142_ sky130_fd_sc_hd__clkbuf_1
XFILLER_0_5_373 VGND VGND VPWR VPWR sky130_fd_sc_hd__fill_2
XTAP_TAPCELL_ROW_96_1170 VGND VPWR sky130_fd_sc_hd__tapvpwrvgnd_1
XTAP_TAPCELL_ROW_96_1181 VGND VPWR sky130_fd_sc_hd__tapvpwrvgnd_1
XFILLER_0_13_195 VGND VGND VPWR VPWR sky130_fd_sc_hd__decap_8
X_4509_ clknet_leaf_59_clk _0240_ net13 VGND VGND VPWR VPWR tree_instances\[5\].u_tree.pipeline_frame_id\[0\]\[0\]
+ sky130_fd_sc_hd__dfrtp_1
XFILLER_0_41_482 VGND VGND VPWR VPWR sky130_fd_sc_hd__fill_2
Xwire1 clk VGND VGND VPWR VPWR net15 sky130_fd_sc_hd__clkbuf_2
XANTENNA__4766__RESET_B net10 VGND VGND VPWR VPWR sky130_fd_sc_hd__diode_2
XFILLER_0_6_81 VGND VGND VPWR VPWR sky130_fd_sc_hd__decap_3
Xclkbuf_leaf_38_clk clknet_3_7__leaf_clk VGND VGND VPWR VPWR clknet_leaf_38_clk sky130_fd_sc_hd__clkbuf_4
XFILLER_0_68_313 VGND VGND VPWR VPWR sky130_fd_sc_hd__fill_1
XTAP_TAPCELL_ROW_72_926 VGND VPWR sky130_fd_sc_hd__tapvpwrvgnd_1
XFILLER_0_68_324 VPWR VGND VPWR VGND sky130_ef_sc_hd__decap_12
XFILLER_0_95_143 VGND VGND VPWR VPWR sky130_fd_sc_hd__fill_1
XFILLER_0_36_210 VGND VGND VPWR VPWR sky130_fd_sc_hd__decap_8
XFILLER_0_91_393 VGND VGND VPWR VPWR sky130_fd_sc_hd__decap_8
XFILLER_0_51_279 VGND VGND VPWR VPWR sky130_fd_sc_hd__fill_1
XANTENNA__4436__RESET_B net13 VGND VGND VPWR VPWR sky130_fd_sc_hd__diode_2
Xclkbuf_leaf_29_clk clknet_3_6__leaf_clk VGND VGND VPWR VPWR clknet_leaf_29_clk sky130_fd_sc_hd__clkbuf_4
XFILLER_0_63_36 VGND VGND VPWR VPWR sky130_fd_sc_hd__fill_1
XFILLER_0_74_305 VGND VGND VPWR VPWR sky130_fd_sc_hd__decap_3
X_4860_ clknet_leaf_43_clk _0541_ net10 VGND VGND VPWR VPWR tree_instances\[19\].u_tree.frame_id_out\[1\]
+ sky130_fd_sc_hd__dfrtp_1
XFILLER_0_59_357 VGND VGND VPWR VPWR sky130_fd_sc_hd__fill_2
X_3811_ _1248_ VGND VGND VPWR VPWR _0350_ sky130_fd_sc_hd__clkbuf_1
X_4791_ clknet_leaf_44_clk _0479_ net13 VGND VGND VPWR VPWR tree_instances\[16\].u_tree.frame_id_out\[3\]
+ sky130_fd_sc_hd__dfrtp_1
XTAP_TAPCELL_ROW_15_363 VGND VPWR sky130_fd_sc_hd__tapvpwrvgnd_1
X_3742_ _1026_ _1209_ VGND VGND VPWR VPWR _1213_ sky130_fd_sc_hd__and2_1
XFILLER_0_6_137 VGND VGND VPWR VPWR sky130_fd_sc_hd__decap_3
XFILLER_0_15_405 VGND VGND VPWR VPWR sky130_fd_sc_hd__decap_8
XFILLER_0_15_416 VGND VGND VPWR VPWR sky130_fd_sc_hd__fill_1
XFILLER_0_70_533 VGND VGND VPWR VPWR sky130_fd_sc_hd__decap_4
XFILLER_0_15_449 VGND VGND VPWR VPWR sky130_fd_sc_hd__fill_2
X_3673_ _1171_ VGND VGND VPWR VPWR _0289_ sky130_fd_sc_hd__clkbuf_1
X_2624_ tree_instances\[19\].u_tree.tree_state\[2\] _1951_ tree_instances\[19\].u_tree.tree_state\[1\]
+ VGND VGND VPWR VPWR _0062_ sky130_fd_sc_hd__a21o_1
XFILLER_0_2_321 VPWR VGND VPWR VGND sky130_ef_sc_hd__decap_12
XFILLER_0_23_493 VGND VGND VPWR VPWR sky130_fd_sc_hd__fill_1
X_2555_ _1892_ VGND VGND VPWR VPWR _1893_ sky130_fd_sc_hd__buf_1
X_2486_ _1666_ tree_instances\[4\].u_tree.pipeline_valid\[0\] VGND VGND VPWR VPWR
+ _1833_ sky130_fd_sc_hd__or2_1
XFILLER_0_10_187 VGND VGND VPWR VPWR sky130_fd_sc_hd__decap_8
X_4225_ tree_instances\[18\].u_tree.frame_id_out\[1\] tree_instances\[18\].u_tree.pipeline_frame_id\[0\]\[1\]
+ _1670_ VGND VGND VPWR VPWR _1494_ sky130_fd_sc_hd__mux2_1
X_4156_ _1456_ VGND VGND VPWR VPWR _0487_ sky130_fd_sc_hd__clkbuf_1
X_3107_ _0657_ tree_instances\[0\].u_tree.frame_id_out\[3\] VGND VGND VPWR VPWR _0779_
+ sky130_fd_sc_hd__or2_1
X_4087_ _1406_ VGND VGND VPWR VPWR _0468_ sky130_fd_sc_hd__clkbuf_1
X_3038_ _0690_ tree_instances\[7\].u_tree.frame_id_out\[3\] tree_instances\[7\].u_tree.frame_id_out\[4\]
+ _0696_ VGND VGND VPWR VPWR _0710_ sky130_fd_sc_hd__o22a_1
XANTENNA_output6_A net6 VGND VGND VPWR VPWR sky130_fd_sc_hd__diode_2
XFILLER_0_18_210 VPWR VGND VPWR VGND sky130_ef_sc_hd__decap_12
XFILLER_0_92_135 VGND VGND VPWR VPWR sky130_fd_sc_hd__decap_4
XFILLER_0_46_530 VGND VGND VPWR VPWR sky130_fd_sc_hd__fill_2
XFILLER_0_18_298 VGND VGND VPWR VPWR sky130_fd_sc_hd__fill_1
XFILLER_0_33_268 VGND VGND VPWR VPWR sky130_fd_sc_hd__fill_2
XFILLER_0_88_419 VGND VGND VPWR VPWR sky130_fd_sc_hd__fill_1
XFILLER_0_68_121 VPWR VGND VPWR VGND sky130_ef_sc_hd__decap_12
XTAP_TAPCELL_ROW_57_775 VGND VPWR sky130_fd_sc_hd__tapvpwrvgnd_1
XTAP_TAPCELL_ROW_29_499 VGND VPWR sky130_fd_sc_hd__tapvpwrvgnd_1
XFILLER_0_33_39 VPWR VGND VPWR VGND sky130_ef_sc_hd__decap_12
XTAP_TAPCELL_ROW_12_333 VGND VPWR sky130_fd_sc_hd__tapvpwrvgnd_1
XFILLER_0_52_500 VGND VGND VPWR VPWR sky130_fd_sc_hd__decap_3
XFILLER_0_52_533 VPWR VGND VPWR VGND sky130_ef_sc_hd__decap_12
XFILLER_0_12_419 VGND VGND VPWR VPWR sky130_fd_sc_hd__fill_1
XFILLER_0_24_246 VGND VGND VPWR VPWR sky130_fd_sc_hd__fill_2
XANTENNA__4688__RESET_B net11 VGND VGND VPWR VPWR sky130_fd_sc_hd__diode_2
XFILLER_0_20_452 VPWR VGND VPWR VGND sky130_ef_sc_hd__decap_12
XANTENNA__4617__RESET_B tree_instances\[0\].u_tree.rst_n VGND VGND VPWR VPWR sky130_fd_sc_hd__diode_2
X_2340_ _1701_ _1703_ VGND VGND VPWR VPWR _1704_ sky130_fd_sc_hd__nor2_1
X_2271_ tree_instances\[0\].u_tree.tree_state\[2\] _1645_ tree_instances\[0\].u_tree.tree_state\[1\]
+ VGND VGND VPWR VPWR _0044_ sky130_fd_sc_hd__a21o_1
X_4010_ _1366_ VGND VGND VPWR VPWR _0431_ sky130_fd_sc_hd__clkbuf_1
XFILLER_0_74_79 VGND VGND VPWR VPWR sky130_fd_sc_hd__decap_4
XFILLER_0_59_165 VGND VGND VPWR VPWR sky130_fd_sc_hd__fill_1
XTAP_TAPCELL_ROW_82_1033 VGND VPWR sky130_fd_sc_hd__tapvpwrvgnd_1
XFILLER_0_28_530 VGND VGND VPWR VPWR sky130_fd_sc_hd__fill_2
X_4843_ clknet_leaf_48_clk _0524_ net10 VGND VGND VPWR VPWR tree_instances\[18\].u_tree.pipeline_valid\[0\]
+ sky130_fd_sc_hd__dfrtp_1
X_4774_ clknet_leaf_52_clk _0462_ net13 VGND VGND VPWR VPWR tree_instances\[16\].u_tree.pipeline_current_node\[0\]\[0\]
+ sky130_fd_sc_hd__dfrtp_1
X_3725_ tree_instances\[8\].u_tree.tree_state\[0\] _1667_ VGND VGND VPWR VPWR _1200_
+ sky130_fd_sc_hd__nand2_1
XFILLER_0_43_533 VGND VGND VPWR VPWR sky130_fd_sc_hd__decap_4
Xclkbuf_leaf_9_clk clknet_3_2__leaf_clk VGND VGND VPWR VPWR clknet_leaf_9_clk sky130_fd_sc_hd__clkbuf_4
XFILLER_0_15_268 VPWR VGND VPWR VGND sky130_ef_sc_hd__decap_12
XFILLER_0_70_374 VPWR VGND VPWR VGND sky130_ef_sc_hd__decap_12
X_3656_ _1161_ VGND VGND VPWR VPWR _0282_ sky130_fd_sc_hd__clkbuf_1
XFILLER_0_30_238 VPWR VGND VPWR VGND sky130_ef_sc_hd__decap_12
X_3587_ _1116_ VGND VGND VPWR VPWR _0258_ sky130_fd_sc_hd__clkbuf_1
XTAP_TAPCELL_ROW_93_1140 VGND VPWR sky130_fd_sc_hd__tapvpwrvgnd_1
XANTENNA__4358__RESET_B net11 VGND VGND VPWR VPWR sky130_fd_sc_hd__diode_2
XFILLER_0_2_151 VGND VGND VPWR VPWR sky130_fd_sc_hd__decap_8
X_2607_ tree_instances\[15\].u_tree.tree_state\[0\] _1935_ _1936_ VGND VGND VPWR VPWR
+ _0054_ sky130_fd_sc_hd__a21o_1
X_2538_ _1878_ VGND VGND VPWR VPWR _1879_ sky130_fd_sc_hd__clkbuf_1
X_2469_ tree_instances\[4\].u_tree.pipeline_current_node\[0\]\[2\] VGND VGND VPWR
+ VPWR _1820_ sky130_fd_sc_hd__clkbuf_1
X_4208_ _1485_ VGND VGND VPWR VPWR _0510_ sky130_fd_sc_hd__clkbuf_1
XANTENNA__3665__A1 _0925_ VGND VGND VPWR VPWR sky130_fd_sc_hd__diode_2
X_4139_ _1443_ VGND VGND VPWR VPWR _1444_ sky130_fd_sc_hd__dlymetal6s2s_1
XTAP_TAPCELL_ROW_54_745 VGND VPWR sky130_fd_sc_hd__tapvpwrvgnd_1
XTAP_TAPCELL_ROW_26_469 VGND VPWR sky130_fd_sc_hd__tapvpwrvgnd_1
XFILLER_0_38_316 VGND VGND VPWR VPWR sky130_fd_sc_hd__decap_8
XFILLER_0_38_338 VGND VGND VPWR VPWR sky130_fd_sc_hd__fill_2
XFILLER_0_93_488 VPWR VGND VPWR VGND sky130_ef_sc_hd__decap_12
XFILLER_0_80_105 VGND VGND VPWR VPWR sky130_fd_sc_hd__decap_8
XFILLER_0_53_319 VGND VGND VPWR VPWR sky130_fd_sc_hd__decap_3
XFILLER_0_80_138 VGND VGND VPWR VPWR sky130_fd_sc_hd__fill_2
XFILLER_0_34_533 VPWR VGND VPWR VGND sky130_ef_sc_hd__decap_12
XFILLER_0_61_363 VGND VGND VPWR VPWR sky130_fd_sc_hd__fill_2
XFILLER_0_21_205 VPWR VGND VPWR VGND sky130_ef_sc_hd__decap_12
XANTENNA__4781__RESET_B net13 VGND VGND VPWR VPWR sky130_fd_sc_hd__diode_2
XFILLER_0_21_238 VGND VGND VPWR VPWR sky130_fd_sc_hd__fill_2
XANTENNA__4710__RESET_B net9 VGND VGND VPWR VPWR sky130_fd_sc_hd__diode_2
XFILLER_0_44_27 VGND VGND VPWR VPWR sky130_fd_sc_hd__fill_1
XFILLER_0_29_327 VGND VGND VPWR VPWR sky130_fd_sc_hd__fill_2
XFILLER_0_96_293 VPWR VGND VPWR VGND sky130_ef_sc_hd__decap_12
XFILLER_0_60_26 VGND VGND VPWR VPWR sky130_fd_sc_hd__fill_2
Xclkbuf_3_4__f_clk clknet_0_clk VGND VGND VPWR VPWR clknet_3_4__leaf_clk sky130_fd_sc_hd__clkbuf_16
XANTENNA__4869__RESET_B net10 VGND VGND VPWR VPWR sky130_fd_sc_hd__diode_2
XFILLER_0_37_382 VGND VGND VPWR VPWR sky130_fd_sc_hd__decap_8
XFILLER_0_37_393 VPWR VGND VPWR VGND sky130_ef_sc_hd__decap_12
XFILLER_0_8_27 VGND VGND VPWR VPWR sky130_fd_sc_hd__fill_1
X_3510_ tree_instances\[5\].u_tree.pipeline_current_node\[0\]\[3\] VGND VGND VPWR
+ VPWR _1064_ sky130_fd_sc_hd__clkbuf_1
XFILLER_0_69_57 VGND VGND VPWR VPWR sky130_fd_sc_hd__decap_8
XFILLER_0_8_49 VGND VGND VPWR VPWR sky130_fd_sc_hd__fill_2
X_4490_ clknet_leaf_60_clk _0100_ tree_instances\[0\].u_tree.rst_n VGND VGND VPWR
+ VPWR tree_instances\[4\].u_tree.prediction_valid sky130_fd_sc_hd__dfrtp_1
XFILLER_0_40_536 VPWR VGND VPWR VGND sky130_ef_sc_hd__decap_12
XFILLER_0_52_396 VPWR VGND VPWR VGND sky130_ef_sc_hd__decap_12
XFILLER_0_12_238 VGND VGND VPWR VPWR sky130_fd_sc_hd__decap_4
X_3441_ tree_instances\[9\].u_tree.pipeline_current_node\[0\]\[3\] VGND VGND VPWR
+ VPWR _1020_ sky130_fd_sc_hd__clkbuf_1
XANTENNA__4451__RESET_B tree_instances\[0\].u_tree.rst_n VGND VGND VPWR VPWR sky130_fd_sc_hd__diode_2
X_3372_ tree_instances\[2\].u_tree.pipeline_frame_id\[0\]\[0\] _0665_ _0028_ VGND
+ VGND VPWR VPWR _0983_ sky130_fd_sc_hd__mux2_1
XFILLER_0_85_34 VGND VGND VPWR VPWR sky130_fd_sc_hd__fill_2
XFILLER_0_20_271 VPWR VGND VPWR VGND sky130_ef_sc_hd__decap_12
X_2323_ tree_instances\[15\].u_tree.pipeline_current_node\[0\]\[3\] VGND VGND VPWR
+ VPWR _1689_ sky130_fd_sc_hd__clkbuf_1
X_2254_ _1628_ VGND VGND VPWR VPWR _1629_ sky130_fd_sc_hd__clkbuf_1
X_2185_ tree_instances\[12\].u_tree.pipeline_current_node\[0\]\[5\] VGND VGND VPWR
+ VPWR _1568_ sky130_fd_sc_hd__clkbuf_1
XFILLER_0_87_260 VGND VGND VPWR VPWR sky130_fd_sc_hd__fill_2
XANTENNA__2165__C _1548_ VGND VGND VPWR VPWR sky130_fd_sc_hd__diode_2
XFILLER_0_75_400 VGND VGND VPWR VPWR sky130_fd_sc_hd__decap_6
XANTENNA__4544__SET_B net13 VGND VGND VPWR VPWR sky130_fd_sc_hd__diode_2
XTAP_TAPCELL_ROW_51_715 VGND VPWR sky130_fd_sc_hd__tapvpwrvgnd_1
XFILLER_0_62_105 VGND VGND VPWR VPWR sky130_fd_sc_hd__fill_2
XTAP_TAPCELL_ROW_23_439 VGND VPWR sky130_fd_sc_hd__tapvpwrvgnd_1
X_4826_ clknet_leaf_50_clk _0508_ net10 VGND VGND VPWR VPWR tree_instances\[18\].u_tree.pipeline_current_node\[0\]\[4\]
+ sky130_fd_sc_hd__dfrtp_1
XFILLER_0_90_425 VGND VGND VPWR VPWR sky130_fd_sc_hd__decap_6
XFILLER_0_62_138 VGND VGND VPWR VPWR sky130_fd_sc_hd__fill_2
XFILLER_0_62_127 VGND VGND VPWR VPWR sky130_fd_sc_hd__fill_1
XFILLER_0_16_533 VPWR VGND VPWR VGND sky130_ef_sc_hd__decap_12
XANTENNA__4539__RESET_B net11 VGND VGND VPWR VPWR sky130_fd_sc_hd__diode_2
XFILLER_0_43_341 VPWR VGND VPWR VGND sky130_ef_sc_hd__decap_12
X_4757_ clknet_leaf_49_clk _0454_ net10 VGND VGND VPWR VPWR tree_instances\[15\].u_tree.pipeline_frame_id\[0\]\[4\]
+ sky130_fd_sc_hd__dfrtp_1
XFILLER_0_50_81 VGND VGND VPWR VPWR sky130_fd_sc_hd__decap_3
XFILLER_0_55_190 VGND VGND VPWR VPWR sky130_fd_sc_hd__fill_2
X_4688_ clknet_leaf_14_clk _0392_ net11 VGND VGND VPWR VPWR tree_instances\[12\].u_tree.frame_id_out\[0\]
+ sky130_fd_sc_hd__dfrtp_1
XFILLER_0_70_171 VGND VGND VPWR VPWR sky130_fd_sc_hd__fill_2
X_3708_ tree_instances\[8\].u_tree.pipeline_frame_id\[0\]\[2\] _1165_ _0040_ VGND
+ VGND VPWR VPWR _1191_ sky130_fd_sc_hd__mux2_1
XFILLER_0_31_536 VGND VGND VPWR VPWR sky130_fd_sc_hd__fill_2
X_3639_ _1149_ VGND VGND VPWR VPWR _1150_ sky130_fd_sc_hd__clkbuf_1
XFILLER_0_11_271 VGND VGND VPWR VPWR sky130_fd_sc_hd__fill_2
XTAP_TAPCELL_ROW_67_881 VGND VPWR sky130_fd_sc_hd__tapvpwrvgnd_1
XTAP_TAPCELL_ROW_39_594 VGND VPWR sky130_fd_sc_hd__tapvpwrvgnd_1
XFILLER_0_66_444 VGND VGND VPWR VPWR sky130_fd_sc_hd__fill_2
XFILLER_0_81_414 VGND VGND VPWR VPWR sky130_fd_sc_hd__fill_2
XFILLER_0_19_393 VPWR VGND VPWR VGND sky130_ef_sc_hd__decap_12
XANTENNA__4329__SET_B net9 VGND VGND VPWR VPWR sky130_fd_sc_hd__diode_2
X_3990_ _1356_ VGND VGND VPWR VPWR _0421_ sky130_fd_sc_hd__clkbuf_1
XANTENNA__4054__A1 _1192_ VGND VGND VPWR VPWR sky130_fd_sc_hd__diode_2
XFILLER_0_84_230 VGND VGND VPWR VPWR sky130_fd_sc_hd__fill_2
X_2941_ _0630_ VGND VGND VPWR VPWR _0030_ sky130_fd_sc_hd__inv_2
XFILLER_0_29_113 VPWR VGND VPWR VGND sky130_ef_sc_hd__decap_12
XFILLER_0_57_477 VGND VGND VPWR VPWR sky130_fd_sc_hd__decap_4
XFILLER_0_29_157 VGND VGND VPWR VPWR sky130_fd_sc_hd__fill_2
XTAP_TAPCELL_ROW_20_409 VGND VPWR sky130_fd_sc_hd__tapvpwrvgnd_1
X_2872_ tree_instances\[10\].u_tree.pipeline_current_node\[0\]\[1\] VGND VGND VPWR
+ VPWR _0579_ sky130_fd_sc_hd__clkbuf_1
X_4611_ clknet_leaf_8_clk _0326_ tree_instances\[0\].u_tree.rst_n VGND VGND VPWR VPWR
+ tree_instances\[9\].u_tree.pipeline_frame_id\[0\]\[3\] sky130_fd_sc_hd__dfrtp_1
XANTENNA__2368__A1 _1575_ VGND VGND VPWR VPWR sky130_fd_sc_hd__diode_2
XANTENNA__4632__RESET_B net9 VGND VGND VPWR VPWR sky130_fd_sc_hd__diode_2
XFILLER_0_44_149 VGND VGND VPWR VPWR sky130_fd_sc_hd__decap_3
X_4542_ clknet_leaf_19_clk _0272_ net11 VGND VGND VPWR VPWR tree_instances\[6\].u_tree.ready_for_next
+ sky130_fd_sc_hd__dfstp_1
XFILLER_0_4_235 VPWR VGND VPWR VGND sky130_ef_sc_hd__decap_12
XFILLER_0_25_374 VPWR VGND VPWR VGND sky130_ef_sc_hd__decap_12
X_4473_ clknet_leaf_65_clk _0213_ tree_instances\[0\].u_tree.rst_n VGND VGND VPWR
+ VPWR tree_instances\[4\].u_tree.pipeline_current_node\[0\]\[3\] sky130_fd_sc_hd__dfrtp_1
XFILLER_0_20_62 VGND VGND VPWR VPWR sky130_fd_sc_hd__fill_2
X_3424_ tree_instances\[3\].u_tree.pipeline_frame_id\[0\]\[4\] _0682_ _0030_ VGND
+ VGND VPWR VPWR _1010_ sky130_fd_sc_hd__mux2_1
XTAP_TAPCELL_ROW_90_1110 VGND VPWR sky130_fd_sc_hd__tapvpwrvgnd_1
X_3355_ _0971_ VGND VGND VPWR VPWR _0171_ sky130_fd_sc_hd__clkbuf_1
XFILLER_0_29_60 VGND VGND VPWR VPWR sky130_fd_sc_hd__fill_2
X_3286_ tree_instances\[0\].u_tree.frame_id_out\[3\] tree_instances\[0\].u_tree.pipeline_frame_id\[0\]\[3\]
+ _1832_ VGND VGND VPWR VPWR _0931_ sky130_fd_sc_hd__mux2_1
X_2306_ _1673_ VGND VGND VPWR VPWR _1674_ sky130_fd_sc_hd__clkbuf_1
X_2237_ tree_instances\[11\].u_tree.tree_state\[2\] _1613_ tree_instances\[11\].u_tree.tree_state\[1\]
+ VGND VGND VPWR VPWR _0047_ sky130_fd_sc_hd__a21o_1
XFILLER_0_24_3 VPWR VGND VPWR VGND sky130_ef_sc_hd__decap_12
X_2168_ tree_instances\[8\].u_tree.ready_for_next _1550_ _1551_ VGND VGND VPWR VPWR
+ _1552_ sky130_fd_sc_hd__and3_1
XFILLER_0_45_81 VPWR VGND VPWR VGND sky130_ef_sc_hd__decap_12
XFILLER_0_95_517 VPWR VGND VPWR VGND sky130_ef_sc_hd__decap_12
XTAP_TAPCELL_ROW_64_851 VGND VPWR sky130_fd_sc_hd__tapvpwrvgnd_1
XFILLER_0_48_411 VGND VGND VPWR VPWR sky130_fd_sc_hd__decap_3
XTAP_TAPCELL_ROW_36_564 VGND VPWR sky130_fd_sc_hd__tapvpwrvgnd_1
XANTENNA__2192__A net1 VGND VGND VPWR VPWR sky130_fd_sc_hd__diode_2
XFILLER_0_63_414 VPWR VGND VPWR VGND sky130_ef_sc_hd__decap_12
XANTENNA__4373__RESET_B net12 VGND VGND VPWR VPWR sky130_fd_sc_hd__diode_2
XPHY_EDGE_ROW_17_Right_17 VGND VGND VPWR VPWR sky130_fd_sc_hd__decap_3
X_4809_ clknet_leaf_46_clk _0496_ net13 VGND VGND VPWR VPWR tree_instances\[17\].u_tree.pipeline_frame_id\[0\]\[4\]
+ sky130_fd_sc_hd__dfrtp_1
XFILLER_0_16_363 VGND VGND VPWR VPWR sky130_fd_sc_hd__fill_1
XFILLER_0_16_385 VGND VGND VPWR VPWR sky130_fd_sc_hd__fill_1
XFILLER_0_9_81 VGND VGND VPWR VPWR sky130_fd_sc_hd__decap_8
XTAP_TAPCELL_ROW_8_289 VGND VPWR sky130_fd_sc_hd__tapvpwrvgnd_1
XPHY_EDGE_ROW_26_Right_26 VGND VGND VPWR VPWR sky130_fd_sc_hd__decap_3
XFILLER_0_86_506 VGND VGND VPWR VPWR sky130_fd_sc_hd__fill_2
XFILLER_0_66_230 VPWR VGND VPWR VGND sky130_ef_sc_hd__decap_12
XFILLER_0_26_105 VGND VGND VPWR VPWR sky130_fd_sc_hd__fill_2
XFILLER_0_26_138 VGND VGND VPWR VPWR sky130_fd_sc_hd__fill_2
XPHY_EDGE_ROW_35_Right_35 VGND VGND VPWR VPWR sky130_fd_sc_hd__decap_3
XFILLER_0_54_414 VGND VGND VPWR VPWR sky130_fd_sc_hd__decap_3
XFILLER_0_10_528 VGND VGND VPWR VPWR sky130_fd_sc_hd__decap_4
XANTENNA__2976__S _0645_ VGND VGND VPWR VPWR sky130_fd_sc_hd__diode_2
XFILLER_0_5_39 VGND VGND VPWR VPWR sky130_fd_sc_hd__decap_8
XPHY_EDGE_ROW_44_Right_44 VGND VGND VPWR VPWR sky130_fd_sc_hd__decap_3
X_3140_ _0686_ tree_instances\[9\].u_tree.frame_id_out\[1\] tree_instances\[9\].u_tree.frame_id_out\[3\]
+ _0691_ _0811_ VGND VGND VPWR VPWR _0812_ sky130_fd_sc_hd__o221a_1
XFILLER_0_89_300 VGND VGND VPWR VPWR sky130_fd_sc_hd__fill_1
XTAP_TAPCELL_ROW_78_987 VGND VPWR sky130_fd_sc_hd__tapvpwrvgnd_1
X_3071_ _0695_ tree_instances\[16\].u_tree.frame_id_out\[4\] tree_instances\[16\].u_tree.frame_id_out\[3\]
+ _0690_ VGND VGND VPWR VPWR _0743_ sky130_fd_sc_hd__o2bb2a_1
XFILLER_0_89_366 VPWR VGND VPWR VGND sky130_ef_sc_hd__decap_12
XFILLER_0_89_388 VGND VGND VPWR VPWR sky130_fd_sc_hd__fill_1
XFILLER_0_77_517 VPWR VGND VPWR VGND sky130_ef_sc_hd__decap_12
XTAP_TAPCELL_ROW_61_821 VGND VPWR sky130_fd_sc_hd__tapvpwrvgnd_1
XANTENNA__4884__RESET_B net12 VGND VGND VPWR VPWR sky130_fd_sc_hd__diode_2
XFILLER_0_85_561 VPWR VGND VPWR VGND sky130_ef_sc_hd__decap_12
X_3973_ _1347_ VGND VGND VPWR VPWR _0413_ sky130_fd_sc_hd__clkbuf_1
XTAP_TAPCELL_ROW_33_534 VGND VPWR sky130_fd_sc_hd__tapvpwrvgnd_1
XANTENNA__4813__RESET_B net12 VGND VGND VPWR VPWR sky130_fd_sc_hd__diode_2
XPHY_EDGE_ROW_53_Right_53 VGND VGND VPWR VPWR sky130_fd_sc_hd__decap_3
X_2924_ _0620_ VGND VGND VPWR VPWR _0036_ sky130_fd_sc_hd__inv_2
X_2855_ _1918_ VGND VGND VPWR VPWR _2157_ sky130_fd_sc_hd__clkbuf_1
XFILLER_0_45_447 VGND VGND VPWR VPWR sky130_fd_sc_hd__fill_1
XFILLER_0_72_299 VGND VGND VPWR VPWR sky130_fd_sc_hd__decap_3
XFILLER_0_60_428 VGND VGND VPWR VPWR sky130_fd_sc_hd__decap_6
X_4525_ clknet_leaf_18_clk _0255_ net11 VGND VGND VPWR VPWR tree_instances\[6\].u_tree.pipeline_current_node\[0\]\[2\]
+ sky130_fd_sc_hd__dfrtp_1
X_2786_ tree_instances\[4\].u_tree.pipeline_current_node\[0\]\[5\] VGND VGND VPWR
+ VPWR _2091_ sky130_fd_sc_hd__clkbuf_1
XFILLER_0_53_480 VPWR VGND VPWR VGND sky130_ef_sc_hd__decap_12
XFILLER_0_40_141 VGND VGND VPWR VPWR sky130_fd_sc_hd__decap_6
XPHY_EDGE_ROW_62_Right_62 VGND VGND VPWR VPWR sky130_fd_sc_hd__decap_3
X_4456_ clknet_leaf_68_clk _0197_ net9 VGND VGND VPWR VPWR tree_instances\[3\].u_tree.pipeline_current_node\[0\]\[8\]
+ sky130_fd_sc_hd__dfrtp_1
X_4387_ clknet_leaf_31_clk _0135_ net13 VGND VGND VPWR VPWR tree_instances\[0\].u_tree.pipeline_frame_id\[0\]\[0\]
+ sky130_fd_sc_hd__dfrtp_1
X_3407_ _1001_ VGND VGND VPWR VPWR _0193_ sky130_fd_sc_hd__clkbuf_1
XFILLER_0_0_293 VPWR VGND VPWR VGND sky130_ef_sc_hd__decap_12
X_3338_ _0957_ VGND VGND VPWR VPWR _0958_ sky130_fd_sc_hd__clkbuf_1
XTAP_TAPCELL_ROW_5_259 VGND VPWR sky130_fd_sc_hd__tapvpwrvgnd_1
XANTENNA_wire10_A net13 VGND VGND VPWR VPWR sky130_fd_sc_hd__diode_2
X_3269_ tree_instances\[0\].u_tree.pipeline_frame_id\[0\]\[0\] _0665_ _0002_ VGND
+ VGND VPWR VPWR _0922_ sky130_fd_sc_hd__mux2_1
XFILLER_0_95_303 VPWR VGND VPWR VGND sky130_ef_sc_hd__decap_12
XFILLER_0_68_539 VGND VGND VPWR VPWR sky130_fd_sc_hd__fill_2
XPHY_EDGE_ROW_71_Right_71 VGND VGND VPWR VPWR sky130_fd_sc_hd__decap_3
XANTENNA__4554__RESET_B tree_instances\[0\].u_tree.rst_n VGND VGND VPWR VPWR sky130_fd_sc_hd__diode_2
XFILLER_0_48_263 VGND VGND VPWR VPWR sky130_fd_sc_hd__fill_2
XFILLER_0_91_520 VPWR VGND VPWR VGND sky130_ef_sc_hd__decap_12
XFILLER_0_63_211 VGND VGND VPWR VPWR sky130_fd_sc_hd__decap_8
XANTENNA__3777__B1 _0042_ VGND VGND VPWR VPWR sky130_fd_sc_hd__diode_2
XFILLER_0_63_277 VGND VGND VPWR VPWR sky130_fd_sc_hd__decap_3
XFILLER_0_51_417 VPWR VGND VPWR VGND sky130_ef_sc_hd__decap_12
XFILLER_0_16_171 VGND VGND VPWR VPWR sky130_fd_sc_hd__fill_2
XANTENNA_clkbuf_leaf_10_clk_A clknet_3_2__leaf_clk VGND VGND VPWR VPWR sky130_fd_sc_hd__diode_2
XPHY_EDGE_ROW_80_Right_80 VGND VGND VPWR VPWR sky130_fd_sc_hd__decap_3
XANTENNA_clkbuf_leaf_25_clk_A clknet_3_6__leaf_clk VGND VGND VPWR VPWR sky130_fd_sc_hd__diode_2
XTAP_TAPCELL_ROW_75_957 VGND VPWR sky130_fd_sc_hd__tapvpwrvgnd_1
XANTENNA__4009__A1 _1165_ VGND VGND VPWR VPWR sky130_fd_sc_hd__diode_2
XFILLER_0_86_358 VGND VGND VPWR VPWR sky130_fd_sc_hd__decap_6
XFILLER_0_86_347 VGND VGND VPWR VPWR sky130_fd_sc_hd__decap_8
XFILLER_0_52_27 VGND VGND VPWR VPWR sky130_fd_sc_hd__fill_1
XFILLER_0_67_561 VPWR VGND VPWR VGND sky130_ef_sc_hd__decap_12
XFILLER_0_39_252 VGND VGND VPWR VPWR sky130_fd_sc_hd__decap_6
XTAP_TAPCELL_ROW_30_504 VGND VPWR sky130_fd_sc_hd__tapvpwrvgnd_1
XFILLER_0_39_274 VGND VGND VPWR VPWR sky130_fd_sc_hd__fill_2
XFILLER_0_27_447 VGND VGND VPWR VPWR sky130_fd_sc_hd__fill_1
X_2640_ tree_instances\[18\].u_tree.tree_state\[2\] _1955_ _1965_ tree_instances\[18\].u_tree.tree_state\[1\]
+ VGND VGND VPWR VPWR _0084_ sky130_fd_sc_hd__a31o_1
X_2571_ _1666_ tree_instances\[20\].u_tree.pipeline_valid\[0\] VGND VGND VPWR VPWR
+ _1907_ sky130_fd_sc_hd__or2_1
XFILLER_0_2_525 VGND VGND VPWR VPWR sky130_fd_sc_hd__decap_6
XFILLER_0_77_24 VPWR VGND VPWR VGND sky130_ef_sc_hd__decap_12
X_4310_ tree_instances\[20\].u_tree.pipeline_frame_id\[0\]\[4\] tree_instances\[0\].u_tree.frame_id_in\[4\]
+ _0026_ VGND VGND VPWR VPWR _1538_ sky130_fd_sc_hd__mux2_1
XFILLER_0_2_569 VGND VGND VPWR VPWR sky130_fd_sc_hd__decap_4
X_4241_ _1989_ _1502_ VGND VGND VPWR VPWR _1503_ sky130_fd_sc_hd__and2_1
X_4172_ tree_instances\[17\].u_tree.pipeline_frame_id\[0\]\[1\] _0672_ _0018_ VGND
+ VGND VPWR VPWR _1467_ sky130_fd_sc_hd__mux2_1
XTAP_TAPCELL_ROW_2_229 VGND VPWR sky130_fd_sc_hd__tapvpwrvgnd_1
X_3123_ _0714_ tree_instances\[2\].u_tree.frame_id_out\[2\] _0792_ _0794_ VGND VGND
+ VPWR VPWR _0795_ sky130_fd_sc_hd__o211a_1
X_3054_ current_voting_frame\[0\] VGND VGND VPWR VPWR _0726_ sky130_fd_sc_hd__buf_4
XTAP_TAPCELL_ROW_46_670 VGND VPWR sky130_fd_sc_hd__tapvpwrvgnd_1
XFILLER_0_92_306 VGND VGND VPWR VPWR sky130_fd_sc_hd__fill_2
XFILLER_0_9_124 VGND VGND VPWR VPWR sky130_fd_sc_hd__decap_8
XFILLER_0_9_113 VGND VGND VPWR VPWR sky130_fd_sc_hd__decap_6
X_3956_ _1714_ _1332_ VGND VGND VPWR VPWR _1339_ sky130_fd_sc_hd__and2_1
XFILLER_0_18_414 VGND VGND VPWR VPWR sky130_fd_sc_hd__fill_2
X_2907_ tree_instances\[9\].u_tree.tree_state\[0\] VGND VGND VPWR VPWR _0609_ sky130_fd_sc_hd__inv_2
XFILLER_0_18_469 VGND VGND VPWR VPWR sky130_fd_sc_hd__decap_6
XFILLER_0_91_3 VGND VGND VPWR VPWR sky130_fd_sc_hd__fill_1
X_3887_ _2020_ _1294_ VGND VGND VPWR VPWR _1296_ sky130_fd_sc_hd__and2_1
XFILLER_0_60_214 VPWR VGND VPWR VGND sky130_ef_sc_hd__decap_12
XFILLER_0_33_417 VGND VGND VPWR VPWR sky130_fd_sc_hd__fill_2
XFILLER_0_45_266 VGND VGND VPWR VPWR sky130_fd_sc_hd__decap_6
X_2838_ tree_instances\[20\].u_tree.pipeline_current_node\[0\]\[2\] VGND VGND VPWR
+ VPWR _2141_ sky130_fd_sc_hd__clkbuf_1
X_2769_ _2076_ VGND VGND VPWR VPWR _2077_ sky130_fd_sc_hd__clkbuf_1
XFILLER_0_13_130 VGND VGND VPWR VPWR sky130_fd_sc_hd__decap_3
XFILLER_0_5_396 VPWR VGND VPWR VGND sky130_ef_sc_hd__decap_12
XFILLER_0_5_385 VGND VGND VPWR VPWR sky130_fd_sc_hd__decap_6
XTAP_TAPCELL_ROW_96_1182 VGND VPWR sky130_fd_sc_hd__tapvpwrvgnd_1
XTAP_TAPCELL_ROW_96_1171 VGND VPWR sky130_fd_sc_hd__tapvpwrvgnd_1
X_4508_ clknet_leaf_52_clk _0239_ net13 VGND VGND VPWR VPWR tree_instances\[5\].u_tree.pipeline_current_node\[0\]\[8\]
+ sky130_fd_sc_hd__dfrtp_1
X_4439_ clknet_leaf_58_clk _0185_ net13 VGND VGND VPWR VPWR tree_instances\[2\].u_tree.frame_id_out\[3\]
+ sky130_fd_sc_hd__dfrtp_1
XFILLER_0_6_93 VGND VGND VPWR VPWR sky130_fd_sc_hd__decap_3
XANTENNA__4735__RESET_B net10 VGND VGND VPWR VPWR sky130_fd_sc_hd__diode_2
XFILLER_0_95_100 VPWR VGND VPWR VGND sky130_ef_sc_hd__decap_12
XANTENNA__2645__A _1574_ VGND VGND VPWR VPWR sky130_fd_sc_hd__diode_2
XTAP_TAPCELL_ROW_72_927 VGND VPWR sky130_fd_sc_hd__tapvpwrvgnd_1
XFILLER_0_68_336 VGND VGND VPWR VPWR sky130_fd_sc_hd__fill_1
XFILLER_0_95_177 VGND VGND VPWR VPWR sky130_fd_sc_hd__fill_1
XFILLER_0_64_553 VPWR VGND VPWR VGND sky130_ef_sc_hd__decap_12
XFILLER_0_64_531 VGND VGND VPWR VPWR sky130_fd_sc_hd__fill_1
XFILLER_0_24_417 VGND VGND VPWR VPWR sky130_fd_sc_hd__decap_3
XFILLER_0_51_236 VGND VGND VPWR VPWR sky130_fd_sc_hd__decap_6
XFILLER_0_32_450 VGND VGND VPWR VPWR sky130_fd_sc_hd__fill_1
XFILLER_0_32_472 VGND VGND VPWR VPWR sky130_fd_sc_hd__fill_2
XFILLER_0_63_15 VGND VGND VPWR VPWR sky130_fd_sc_hd__decap_8
XFILLER_0_2_29 VPWR VGND VPWR VGND sky130_ef_sc_hd__decap_12
XANTENNA__4476__RESET_B net9 VGND VGND VPWR VPWR sky130_fd_sc_hd__diode_2
XANTENNA__4405__RESET_B net11 VGND VGND VPWR VPWR sky130_fd_sc_hd__diode_2
X_4790_ clknet_leaf_43_clk _0478_ net13 VGND VGND VPWR VPWR tree_instances\[16\].u_tree.frame_id_out\[2\]
+ sky130_fd_sc_hd__dfrtp_1
XTAP_TAPCELL_ROW_43_640 VGND VPWR sky130_fd_sc_hd__tapvpwrvgnd_1
X_3810_ tree_instances\[10\].u_tree.frame_id_out\[1\] tree_instances\[10\].u_tree.pipeline_frame_id\[0\]\[1\]
+ _1597_ VGND VGND VPWR VPWR _1248_ sky130_fd_sc_hd__mux2_1
XFILLER_0_67_391 VGND VGND VPWR VPWR sky130_fd_sc_hd__fill_1
X_3741_ _1212_ VGND VGND VPWR VPWR _0316_ sky130_fd_sc_hd__clkbuf_1
XFILLER_0_70_512 VPWR VGND VPWR VGND sky130_ef_sc_hd__decap_12
XFILLER_0_6_149 VGND VGND VPWR VPWR sky130_fd_sc_hd__decap_4
XFILLER_0_27_288 VGND VGND VPWR VPWR sky130_fd_sc_hd__fill_2
XFILLER_0_27_299 VPWR VGND VPWR VGND sky130_ef_sc_hd__decap_12
X_3672_ tree_instances\[7\].u_tree.frame_id_out\[1\] tree_instances\[7\].u_tree.pipeline_frame_id\[0\]\[1\]
+ tree_instances\[7\].u_tree.tree_state\[3\] VGND VGND VPWR VPWR _1171_ sky130_fd_sc_hd__mux2_1
X_2623_ _1946_ _1947_ _1950_ VGND VGND VPWR VPWR _1951_ sky130_fd_sc_hd__and3b_1
XFILLER_0_88_23 VGND VGND VPWR VPWR sky130_fd_sc_hd__fill_2
XFILLER_0_42_258 VGND VGND VPWR VPWR sky130_fd_sc_hd__fill_1
X_2554_ tree_instances\[20\].u_tree.pipeline_current_node\[0\]\[4\] tree_instances\[20\].u_tree.pipeline_current_node\[0\]\[5\]
+ VGND VGND VPWR VPWR _1892_ sky130_fd_sc_hd__or2_1
XFILLER_0_2_333 VGND VGND VPWR VPWR sky130_fd_sc_hd__fill_1
XFILLER_0_50_291 VGND VGND VPWR VPWR sky130_fd_sc_hd__decap_4
X_2485_ tree_instances\[0\].u_tree.tree_state\[0\] _1831_ _1832_ VGND VGND VPWR VPWR
+ _0043_ sky130_fd_sc_hd__a21o_1
X_4224_ _1493_ VGND VGND VPWR VPWR _0518_ sky130_fd_sc_hd__clkbuf_1
X_4155_ _1455_ _1444_ VGND VGND VPWR VPWR _1456_ sky130_fd_sc_hd__and2_1
X_3106_ _0657_ tree_instances\[0\].u_tree.frame_id_out\[3\] VGND VGND VPWR VPWR _0778_
+ sky130_fd_sc_hd__nand2_1
X_4086_ _2060_ _1399_ VGND VGND VPWR VPWR _1406_ sky130_fd_sc_hd__and2_1
XFILLER_0_77_111 VGND VGND VPWR VPWR sky130_fd_sc_hd__fill_1
X_3037_ _0647_ tree_instances\[7\].u_tree.frame_id_out\[0\] tree_instances\[7\].u_tree.frame_id_out\[2\]
+ _0704_ VGND VGND VPWR VPWR _0709_ sky130_fd_sc_hd__o22a_1
XFILLER_0_58_380 VPWR VGND VPWR VGND sky130_ef_sc_hd__decap_12
XFILLER_0_18_222 VPWR VGND VPWR VGND sky130_ef_sc_hd__decap_12
XFILLER_0_92_169 VGND VGND VPWR VPWR sky130_fd_sc_hd__fill_1
X_3939_ _1316_ VGND VGND VPWR VPWR _1329_ sky130_fd_sc_hd__clkbuf_1
XFILLER_0_33_225 VPWR VGND VPWR VGND sky130_ef_sc_hd__decap_12
XANTENNA__3380__A1 _0682_ VGND VGND VPWR VPWR sky130_fd_sc_hd__diode_2
XPHY_EDGE_ROW_92_Left_189 VGND VGND VPWR VPWR sky130_fd_sc_hd__decap_3
XANTENNA__3132__A1 _0647_ VGND VGND VPWR VPWR sky130_fd_sc_hd__diode_2
XANTENNA__3132__B2 _0661_ VGND VGND VPWR VPWR sky130_fd_sc_hd__diode_2
XTAP_TAPCELL_ROW_57_776 VGND VPWR sky130_fd_sc_hd__tapvpwrvgnd_1
XFILLER_0_68_133 VGND VGND VPWR VPWR sky130_fd_sc_hd__decap_6
XPHY_EDGE_ROW_1_Left_98 VGND VGND VPWR VPWR sky130_fd_sc_hd__decap_3
XFILLER_0_29_509 VPWR VGND VPWR VGND sky130_ef_sc_hd__decap_12
XTAP_TAPCELL_ROW_40_610 VGND VPWR sky130_fd_sc_hd__tapvpwrvgnd_1
XFILLER_0_49_391 VGND VGND VPWR VPWR sky130_fd_sc_hd__fill_1
XFILLER_0_83_169 VGND VGND VPWR VPWR sky130_fd_sc_hd__decap_8
XFILLER_0_64_361 VGND VGND VPWR VPWR sky130_fd_sc_hd__decap_3
XFILLER_0_52_545 VPWR VGND VPWR VGND sky130_ef_sc_hd__decap_12
XFILLER_0_3_119 VGND VGND VPWR VPWR sky130_fd_sc_hd__decap_6
XFILLER_0_58_15 VPWR VGND VPWR VGND sky130_ef_sc_hd__decap_12
X_2270_ _1644_ VGND VGND VPWR VPWR _1645_ sky130_fd_sc_hd__inv_2
XFILLER_0_20_486 VGND VGND VPWR VPWR sky130_fd_sc_hd__fill_1
XANTENNA__4657__RESET_B tree_instances\[0\].u_tree.rst_n VGND VGND VPWR VPWR sky130_fd_sc_hd__diode_2
XANTENNA__4320__A0 tree_instances\[20\].u_tree.frame_id_out\[4\] VGND VGND VPWR VPWR
+ sky130_fd_sc_hd__diode_2
XANTENNA__3123__A1 _0714_ VGND VGND VPWR VPWR sky130_fd_sc_hd__diode_2
XFILLER_0_87_486 VGND VGND VPWR VPWR sky130_fd_sc_hd__fill_1
XFILLER_0_28_520 VGND VGND VPWR VPWR sky130_fd_sc_hd__decap_4
XFILLER_0_28_542 VPWR VGND VPWR VGND sky130_ef_sc_hd__decap_12
X_4842_ clknet_leaf_46_clk _0094_ net13 VGND VGND VPWR VPWR tree_instances\[18\].u_tree.prediction_valid
+ sky130_fd_sc_hd__dfrtp_1
XFILLER_0_62_309 VPWR VGND VPWR VGND sky130_ef_sc_hd__decap_12
X_4773_ clknet_leaf_56_clk _0461_ tree_instances\[0\].u_tree.rst_n VGND VGND VPWR
+ VPWR tree_instances\[2\].u_tree.pipeline_valid\[0\] sky130_fd_sc_hd__dfrtp_1
XFILLER_0_55_350 VGND VGND VPWR VPWR sky130_fd_sc_hd__fill_2
X_3724_ _1199_ VGND VGND VPWR VPWR _0312_ sky130_fd_sc_hd__clkbuf_1
X_3655_ tree_instances\[7\].u_tree.pipeline_current_node\[0\]\[8\] _1138_ VGND VGND
+ VPWR VPWR _1161_ sky130_fd_sc_hd__and2_1
XFILLER_0_70_386 VGND VGND VPWR VPWR sky130_fd_sc_hd__fill_1
X_2606_ tree_instances\[15\].u_tree.tree_state\[3\] VGND VGND VPWR VPWR _1936_ sky130_fd_sc_hd__buf_2
X_3586_ _1115_ _1096_ VGND VGND VPWR VPWR _1116_ sky130_fd_sc_hd__and2_1
XTAP_TAPCELL_ROW_93_1141 VGND VPWR sky130_fd_sc_hd__tapvpwrvgnd_1
XFILLER_0_2_141 VGND VGND VPWR VPWR sky130_fd_sc_hd__fill_1
X_2537_ tree_instances\[2\].u_tree.pipeline_current_node\[0\]\[3\] _1877_ VGND VGND
+ VPWR VPWR _1878_ sky130_fd_sc_hd__or2_1
XFILLER_0_2_185 VGND VGND VPWR VPWR sky130_fd_sc_hd__fill_2
X_2468_ _1818_ VGND VGND VPWR VPWR _1819_ sky130_fd_sc_hd__clkbuf_1
XFILLER_0_54_3 VGND VGND VPWR VPWR sky130_fd_sc_hd__decap_8
XANTENNA__4398__RESET_B net11 VGND VGND VPWR VPWR sky130_fd_sc_hd__diode_2
X_4207_ _1435_ _1478_ VGND VGND VPWR VPWR _1485_ sky130_fd_sc_hd__and2_1
X_2399_ _1557_ _1756_ VGND VGND VPWR VPWR _1757_ sky130_fd_sc_hd__nand2_1
X_4138_ tree_instances\[17\].u_tree.tree_state\[2\] tree_instances\[17\].u_tree.tree_state\[1\]
+ _0604_ VGND VGND VPWR VPWR _1443_ sky130_fd_sc_hd__or3_1
X_4069_ tree_instances\[2\].u_tree.pipeline_valid\[0\] tree_instances\[2\].u_tree.tree_state\[0\]
+ VGND VGND VPWR VPWR _1396_ sky130_fd_sc_hd__nand2_1
XFILLER_0_78_431 VGND VGND VPWR VPWR sky130_fd_sc_hd__decap_8
XTAP_TAPCELL_ROW_54_746 VGND VPWR sky130_fd_sc_hd__tapvpwrvgnd_1
XFILLER_0_78_475 VGND VGND VPWR VPWR sky130_fd_sc_hd__fill_1
XFILLER_0_65_125 VGND VGND VPWR VPWR sky130_fd_sc_hd__fill_1
XFILLER_0_34_501 VGND VGND VPWR VPWR sky130_fd_sc_hd__fill_2
XFILLER_0_34_545 VGND VGND VPWR VPWR sky130_fd_sc_hd__fill_2
XFILLER_0_21_217 VGND VGND VPWR VPWR sky130_fd_sc_hd__decap_6
XANTENNA__4750__RESET_B net10 VGND VGND VPWR VPWR sky130_fd_sc_hd__diode_2
XFILLER_0_69_453 VPWR VGND VPWR VGND sky130_ef_sc_hd__decap_12
XFILLER_0_84_401 VPWR VGND VPWR VGND sky130_ef_sc_hd__decap_12
XFILLER_0_69_475 VGND VGND VPWR VPWR sky130_fd_sc_hd__fill_2
XFILLER_0_56_125 VGND VGND VPWR VPWR sky130_fd_sc_hd__decap_3
XFILLER_0_56_147 VGND VGND VPWR VPWR sky130_fd_sc_hd__fill_1
XFILLER_0_44_309 VGND VGND VPWR VPWR sky130_fd_sc_hd__decap_4
XFILLER_0_69_14 VGND VGND VPWR VPWR sky130_fd_sc_hd__decap_3
XFILLER_0_4_417 VGND VGND VPWR VPWR sky130_fd_sc_hd__decap_3
XFILLER_0_69_47 VGND VGND VPWR VPWR sky130_fd_sc_hd__decap_8
XFILLER_0_40_504 VGND VGND VPWR VPWR sky130_fd_sc_hd__decap_3
X_3440_ _1018_ VGND VGND VPWR VPWR _1019_ sky130_fd_sc_hd__clkbuf_1
XFILLER_0_40_548 VPWR VGND VPWR VGND sky130_ef_sc_hd__decap_12
X_3371_ _0982_ VGND VGND VPWR VPWR _0176_ sky130_fd_sc_hd__clkbuf_1
XANTENNA__4838__RESET_B net13 VGND VGND VPWR VPWR sky130_fd_sc_hd__diode_2
XFILLER_0_20_283 VGND VGND VPWR VPWR sky130_fd_sc_hd__decap_3
X_2322_ tree_instances\[15\].u_tree.pipeline_current_node\[0\]\[8\] VGND VGND VPWR
+ VPWR _1688_ sky130_fd_sc_hd__clkbuf_1
XFILLER_0_85_57 VPWR VGND VPWR VGND sky130_ef_sc_hd__decap_12
X_2253_ tree_instances\[0\].u_tree.pipeline_current_node\[0\]\[3\] VGND VGND VPWR
+ VPWR _1628_ sky130_fd_sc_hd__clkbuf_1
XANTENNA__4420__RESET_B net11 VGND VGND VPWR VPWR sky130_fd_sc_hd__diode_2
X_2184_ tree_instances\[12\].u_tree.pipeline_current_node\[0\]\[8\] _1566_ VGND VGND
+ VPWR VPWR _1567_ sky130_fd_sc_hd__nor2_1
XFILLER_0_19_6 VGND VGND VPWR VPWR sky130_fd_sc_hd__decap_4
XFILLER_0_75_423 VGND VGND VPWR VPWR sky130_fd_sc_hd__fill_2
XFILLER_0_47_125 VGND VGND VPWR VPWR sky130_fd_sc_hd__fill_2
XFILLER_0_47_147 VGND VGND VPWR VPWR sky130_fd_sc_hd__fill_2
XTAP_TAPCELL_ROW_51_716 VGND VPWR sky130_fd_sc_hd__tapvpwrvgnd_1
X_4825_ clknet_leaf_50_clk _0507_ net10 VGND VGND VPWR VPWR tree_instances\[18\].u_tree.pipeline_current_node\[0\]\[3\]
+ sky130_fd_sc_hd__dfrtp_1
XFILLER_0_47_158 VGND VGND VPWR VPWR sky130_fd_sc_hd__fill_2
XFILLER_0_47_169 VGND VGND VPWR VPWR sky130_fd_sc_hd__fill_2
XFILLER_0_16_545 VPWR VGND VPWR VGND sky130_ef_sc_hd__decap_12
XFILLER_0_43_353 VGND VGND VPWR VPWR sky130_fd_sc_hd__decap_6
X_4756_ clknet_leaf_45_clk _0453_ net13 VGND VGND VPWR VPWR tree_instances\[15\].u_tree.pipeline_frame_id\[0\]\[3\]
+ sky130_fd_sc_hd__dfrtp_1
X_4687_ clknet_leaf_14_clk _0391_ net11 VGND VGND VPWR VPWR tree_instances\[12\].u_tree.pipeline_frame_id\[0\]\[4\]
+ sky130_fd_sc_hd__dfrtp_1
X_3707_ _1190_ VGND VGND VPWR VPWR _0304_ sky130_fd_sc_hd__clkbuf_1
XFILLER_0_43_375 VGND VGND VPWR VPWR sky130_fd_sc_hd__fill_2
X_3638_ _1148_ VGND VGND VPWR VPWR _1149_ sky130_fd_sc_hd__clkbuf_1
XFILLER_0_3_461 VPWR VGND VPWR VGND sky130_ef_sc_hd__decap_12
X_3569_ tree_instances\[6\].u_tree.pipeline_current_node\[0\]\[2\] VGND VGND VPWR
+ VPWR _1102_ sky130_fd_sc_hd__clkbuf_1
XANTENNA__4579__RESET_B net12 VGND VGND VPWR VPWR sky130_fd_sc_hd__diode_2
XFILLER_0_11_261 VGND VGND VPWR VPWR sky130_fd_sc_hd__decap_6
XANTENNA__4508__RESET_B net13 VGND VGND VPWR VPWR sky130_fd_sc_hd__diode_2
XTAP_TAPCELL_ROW_67_882 VGND VPWR sky130_fd_sc_hd__tapvpwrvgnd_1
XTAP_TAPCELL_ROW_39_595 VGND VPWR sky130_fd_sc_hd__tapvpwrvgnd_1
XFILLER_0_26_309 VGND VGND VPWR VPWR sky130_fd_sc_hd__decap_4
XFILLER_0_19_361 VPWR VGND VPWR VGND sky130_ef_sc_hd__decap_12
XFILLER_0_61_172 VGND VGND VPWR VPWR sky130_fd_sc_hd__decap_8
XFILLER_0_1_409 VPWR VGND VPWR VGND sky130_ef_sc_hd__decap_12
XANTENNA_clkload3_A clknet_3_5__leaf_clk VGND VGND VPWR VPWR sky130_fd_sc_hd__diode_2
XFILLER_0_71_15 VPWR VGND VPWR VGND sky130_ef_sc_hd__decap_12
X_2940_ _0629_ _1871_ VGND VGND VPWR VPWR _0630_ sky130_fd_sc_hd__or2_1
XFILLER_0_29_125 VPWR VGND VPWR VGND sky130_ef_sc_hd__decap_12
XFILLER_0_29_147 VGND VGND VPWR VPWR sky130_fd_sc_hd__fill_1
XFILLER_0_29_169 VPWR VGND VPWR VGND sky130_ef_sc_hd__decap_12
X_2871_ tree_instances\[10\].u_tree.pipeline_current_node\[0\]\[2\] VGND VGND VPWR
+ VPWR _0578_ sky130_fd_sc_hd__clkbuf_1
X_4610_ clknet_leaf_6_clk _0325_ tree_instances\[0\].u_tree.rst_n VGND VGND VPWR VPWR
+ tree_instances\[9\].u_tree.pipeline_frame_id\[0\]\[2\] sky130_fd_sc_hd__dfrtp_1
X_4541_ clknet_leaf_20_clk _0271_ net11 VGND VGND VPWR VPWR tree_instances\[6\].u_tree.frame_id_out\[4\]
+ sky130_fd_sc_hd__dfrtp_1
XFILLER_0_4_258 VGND VGND VPWR VPWR sky130_fd_sc_hd__fill_2
XFILLER_0_4_247 VGND VGND VPWR VPWR sky130_fd_sc_hd__fill_2
XFILLER_0_20_41 VGND VGND VPWR VPWR sky130_fd_sc_hd__fill_1
XFILLER_0_25_386 VGND VGND VPWR VPWR sky130_fd_sc_hd__decap_6
XFILLER_0_52_161 VGND VGND VPWR VPWR sky130_fd_sc_hd__fill_2
XFILLER_0_13_559 VGND VGND VPWR VPWR sky130_fd_sc_hd__fill_1
X_4472_ clknet_leaf_56_clk _0212_ tree_instances\[0\].u_tree.rst_n VGND VGND VPWR
+ VPWR tree_instances\[4\].u_tree.pipeline_current_node\[0\]\[2\] sky130_fd_sc_hd__dfrtp_1
XFILLER_0_20_85 VGND VGND VPWR VPWR sky130_fd_sc_hd__decap_8
XFILLER_0_40_345 VPWR VGND VPWR VGND sky130_ef_sc_hd__decap_12
X_3423_ _1009_ VGND VGND VPWR VPWR _0201_ sky130_fd_sc_hd__clkbuf_1
XANTENNA__4672__RESET_B tree_instances\[0\].u_tree.rst_n VGND VGND VPWR VPWR sky130_fd_sc_hd__diode_2
XTAP_TAPCELL_ROW_90_1111 VGND VPWR sky130_fd_sc_hd__tapvpwrvgnd_1
XANTENNA__4601__RESET_B net9 VGND VGND VPWR VPWR sky130_fd_sc_hd__diode_2
X_3354_ _0970_ _0960_ VGND VGND VPWR VPWR _0971_ sky130_fd_sc_hd__and2_1
X_3285_ _0930_ VGND VGND VPWR VPWR _0142_ sky130_fd_sc_hd__clkbuf_1
X_2305_ _1671_ _1672_ VGND VGND VPWR VPWR _1673_ sky130_fd_sc_hd__or2_1
X_2236_ _1598_ _1604_ _1611_ _1612_ VGND VGND VPWR VPWR _1613_ sky130_fd_sc_hd__and4_1
XTAP_TAPCELL_ROW_88_1084 VGND VPWR sky130_fd_sc_hd__tapvpwrvgnd_1
X_2167_ tree_instances\[7\].u_tree.ready_for_next tree_instances\[6\].u_tree.ready_for_next
+ tree_instances\[9\].u_tree.ready_for_next VGND VGND VPWR VPWR _1551_ sky130_fd_sc_hd__and3_1
XFILLER_0_17_3 VGND VGND VPWR VPWR sky130_fd_sc_hd__decap_4
XFILLER_0_95_529 VPWR VGND VPWR VGND sky130_ef_sc_hd__decap_12
XTAP_TAPCELL_ROW_64_852 VGND VPWR sky130_fd_sc_hd__tapvpwrvgnd_1
XFILLER_0_45_93 VPWR VGND VPWR VGND sky130_ef_sc_hd__decap_12
XTAP_TAPCELL_ROW_36_565 VGND VPWR sky130_fd_sc_hd__tapvpwrvgnd_1
XFILLER_0_75_253 VPWR VGND VPWR VGND sky130_ef_sc_hd__decap_12
XFILLER_0_8_531 VGND VGND VPWR VPWR sky130_fd_sc_hd__fill_1
XFILLER_0_48_456 VGND VGND VPWR VPWR sky130_fd_sc_hd__fill_2
XFILLER_0_90_201 VPWR VGND VPWR VGND sky130_ef_sc_hd__decap_12
XFILLER_0_63_426 VPWR VGND VPWR VGND sky130_ef_sc_hd__decap_12
XFILLER_0_61_81 VGND VGND VPWR VPWR sky130_fd_sc_hd__decap_6
X_4808_ clknet_leaf_45_clk _0495_ net12 VGND VGND VPWR VPWR tree_instances\[17\].u_tree.pipeline_frame_id\[0\]\[3\]
+ sky130_fd_sc_hd__dfrtp_1
X_4739_ clknet_leaf_22_clk _0437_ net11 VGND VGND VPWR VPWR tree_instances\[14\].u_tree.frame_id_out\[3\]
+ sky130_fd_sc_hd__dfrtp_1
XFILLER_0_50_109 VPWR VGND VPWR VGND sky130_ef_sc_hd__decap_12
XFILLER_0_31_345 VGND VGND VPWR VPWR sky130_fd_sc_hd__decap_3
XANTENNA__4342__RESET_B tree_instances\[0\].u_tree.rst_n VGND VGND VPWR VPWR sky130_fd_sc_hd__diode_2
XFILLER_0_94_573 VGND VGND VPWR VPWR sky130_fd_sc_hd__fill_1
XFILLER_0_66_253 VGND VGND VPWR VPWR sky130_fd_sc_hd__decap_3
XFILLER_0_81_223 VGND VGND VPWR VPWR sky130_fd_sc_hd__fill_1
XFILLER_0_81_201 VGND VGND VPWR VPWR sky130_fd_sc_hd__decap_8
XFILLER_0_81_278 VGND VGND VPWR VPWR sky130_fd_sc_hd__fill_2
XFILLER_0_22_301 VGND VGND VPWR VPWR sky130_fd_sc_hd__fill_2
XFILLER_0_66_26 VGND VGND VPWR VPWR sky130_fd_sc_hd__fill_2
X_3070_ _0648_ tree_instances\[16\].u_tree.frame_id_out\[0\] _0741_ VGND VGND VPWR
+ VPWR _0742_ sky130_fd_sc_hd__a21oi_1
XTAP_TAPCELL_ROW_78_988 VGND VPWR sky130_fd_sc_hd__tapvpwrvgnd_1
XFILLER_0_89_378 VGND VGND VPWR VPWR sky130_fd_sc_hd__decap_6
XFILLER_0_82_69 VPWR VGND VPWR VGND sky130_ef_sc_hd__decap_12
XFILLER_0_77_529 VGND VGND VPWR VPWR sky130_fd_sc_hd__decap_3
XTAP_TAPCELL_ROW_61_822 VGND VPWR sky130_fd_sc_hd__tapvpwrvgnd_1
XFILLER_0_57_242 VPWR VGND VPWR VGND sky130_ef_sc_hd__decap_12
XFILLER_0_9_317 VGND VGND VPWR VPWR sky130_fd_sc_hd__fill_2
XTAP_TAPCELL_ROW_33_535 VGND VPWR sky130_fd_sc_hd__tapvpwrvgnd_1
X_3972_ tree_instances\[13\].u_tree.frame_id_out\[0\] tree_instances\[13\].u_tree.pipeline_frame_id\[0\]\[0\]
+ _1577_ VGND VGND VPWR VPWR _1347_ sky130_fd_sc_hd__mux2_1
XFILLER_0_85_573 VGND VGND VPWR VPWR sky130_fd_sc_hd__fill_1
X_2923_ _0619_ _1751_ VGND VGND VPWR VPWR _0620_ sky130_fd_sc_hd__or2_1
XFILLER_0_17_106 VGND VGND VPWR VPWR sky130_fd_sc_hd__decap_3
X_2854_ tree_instances\[1\].u_tree.pipeline_current_node\[0\]\[0\] VGND VGND VPWR
+ VPWR _2156_ sky130_fd_sc_hd__clkbuf_1
XANTENNA__4853__RESET_B net10 VGND VGND VPWR VPWR sky130_fd_sc_hd__diode_2
X_2785_ _2090_ VGND VGND VPWR VPWR _0092_ sky130_fd_sc_hd__clkbuf_1
X_4524_ clknet_leaf_18_clk _0254_ net11 VGND VGND VPWR VPWR tree_instances\[6\].u_tree.pipeline_current_node\[0\]\[1\]
+ sky130_fd_sc_hd__dfrtp_1
XFILLER_0_53_492 VPWR VGND VPWR VGND sky130_ef_sc_hd__decap_12
X_4455_ clknet_leaf_68_clk _0196_ net9 VGND VGND VPWR VPWR tree_instances\[3\].u_tree.pipeline_current_node\[0\]\[7\]
+ sky130_fd_sc_hd__dfrtp_1
X_4386_ clknet_leaf_36_clk _0134_ net10 VGND VGND VPWR VPWR tree_instances\[0\].u_tree.pipeline_current_node\[0\]\[8\]
+ sky130_fd_sc_hd__dfrtp_1
X_3406_ _2118_ _0996_ VGND VGND VPWR VPWR _1001_ sky130_fd_sc_hd__and2_1
XFILLER_0_40_197 VGND VGND VPWR VPWR sky130_fd_sc_hd__decap_4
XTAP_TAPCELL_ROW_69_900 VGND VPWR sky130_fd_sc_hd__tapvpwrvgnd_1
X_3337_ _1874_ VGND VGND VPWR VPWR _0957_ sky130_fd_sc_hd__clkbuf_1
X_3268_ _0921_ VGND VGND VPWR VPWR _0134_ sky130_fd_sc_hd__clkbuf_1
X_3199_ _0864_ _0866_ _0870_ VGND VGND VPWR VPWR _0871_ sky130_fd_sc_hd__and3_1
X_2219_ tree_instances\[10\].u_tree.tree_state\[3\] VGND VGND VPWR VPWR _1597_ sky130_fd_sc_hd__buf_2
XFILLER_0_95_315 VGND VGND VPWR VPWR sky130_fd_sc_hd__decap_6
XFILLER_0_95_337 VPWR VGND VPWR VGND sky130_ef_sc_hd__decap_12
XFILLER_0_48_231 VGND VGND VPWR VPWR sky130_fd_sc_hd__fill_2
XFILLER_0_48_242 VGND VGND VPWR VPWR sky130_fd_sc_hd__fill_2
XFILLER_0_48_253 VGND VGND VPWR VPWR sky130_fd_sc_hd__fill_2
XFILLER_0_76_573 VGND VGND VPWR VPWR sky130_fd_sc_hd__fill_1
XFILLER_0_48_275 VGND VGND VPWR VPWR sky130_fd_sc_hd__decap_3
XFILLER_0_91_532 VPWR VGND VPWR VGND sky130_ef_sc_hd__decap_12
XFILLER_0_8_372 VPWR VGND VPWR VGND sky130_ef_sc_hd__decap_12
XANTENNA__4594__RESET_B net12 VGND VGND VPWR VPWR sky130_fd_sc_hd__diode_2
XFILLER_0_8_394 VGND VGND VPWR VPWR sky130_fd_sc_hd__fill_1
XFILLER_0_51_429 VPWR VGND VPWR VGND sky130_ef_sc_hd__decap_12
XANTENNA__4523__RESET_B net11 VGND VGND VPWR VPWR sky130_fd_sc_hd__diode_2
XFILLER_0_44_470 VGND VGND VPWR VPWR sky130_fd_sc_hd__decap_6
XFILLER_0_6_3 VPWR VGND VPWR VGND sky130_ef_sc_hd__decap_12
XTAP_TAPCELL_ROW_75_958 VGND VPWR sky130_fd_sc_hd__tapvpwrvgnd_1
XANTENNA_load_slew11_A net13 VGND VGND VPWR VPWR sky130_fd_sc_hd__diode_2
XFILLER_0_67_573 VGND VGND VPWR VPWR sky130_fd_sc_hd__fill_1
XTAP_TAPCELL_ROW_30_505 VGND VPWR sky130_fd_sc_hd__tapvpwrvgnd_1
X_2570_ _1906_ _1812_ _1824_ tree_instances\[4\].u_tree.tree_state\[2\] VGND VGND
+ VPWR VPWR _0031_ sky130_fd_sc_hd__o31a_1
XFILLER_0_77_36 VPWR VGND VPWR VGND sky130_ef_sc_hd__decap_12
XFILLER_0_22_164 VGND VGND VPWR VPWR sky130_fd_sc_hd__fill_2
X_4240_ _1501_ VGND VGND VPWR VPWR _1502_ sky130_fd_sc_hd__dlymetal6s2s_1
X_4171_ _1466_ VGND VGND VPWR VPWR _0492_ sky130_fd_sc_hd__clkbuf_1
X_3122_ _0647_ tree_instances\[2\].u_tree.frame_id_out\[0\] tree_instances\[2\].u_tree.frame_id_out\[3\]
+ _0702_ _0793_ VGND VGND VPWR VPWR _0794_ sky130_fd_sc_hd__o221a_1
XFILLER_0_93_57 VGND VGND VPWR VPWR sky130_fd_sc_hd__fill_2
X_3053_ _0685_ tree_instances\[15\].u_tree.frame_id_out\[1\] tree_instances\[15\].u_tree.frame_id_out\[2\]
+ _0704_ VGND VGND VPWR VPWR _0725_ sky130_fd_sc_hd__a22o_1
XFILLER_0_26_73 VGND VGND VPWR VPWR sky130_fd_sc_hd__fill_2
XTAP_TAPCELL_ROW_85_1054 VGND VPWR sky130_fd_sc_hd__tapvpwrvgnd_1
XFILLER_0_77_337 VGND VGND VPWR VPWR sky130_fd_sc_hd__fill_2
XTAP_TAPCELL_ROW_18_384 VGND VPWR sky130_fd_sc_hd__tapvpwrvgnd_1
XTAP_TAPCELL_ROW_46_671 VGND VPWR sky130_fd_sc_hd__tapvpwrvgnd_1
XFILLER_0_85_370 VPWR VGND VPWR VGND sky130_ef_sc_hd__decap_12
X_3955_ _1338_ VGND VGND VPWR VPWR _0404_ sky130_fd_sc_hd__clkbuf_1
XFILLER_0_73_532 VPWR VGND VPWR VGND sky130_ef_sc_hd__decap_12
X_2906_ _0608_ VGND VGND VPWR VPWR _0006_ sky130_fd_sc_hd__inv_2
XFILLER_0_45_234 VGND VGND VPWR VPWR sky130_fd_sc_hd__fill_2
X_3886_ _1295_ VGND VGND VPWR VPWR _0378_ sky130_fd_sc_hd__clkbuf_1
XFILLER_0_60_204 VGND VGND VPWR VPWR sky130_fd_sc_hd__decap_4
XFILLER_0_5_331 VGND VGND VPWR VPWR sky130_fd_sc_hd__decap_4
XFILLER_0_84_3 VPWR VGND VPWR VGND sky130_ef_sc_hd__decap_12
X_2837_ tree_instances\[20\].u_tree.pipeline_current_node\[0\]\[0\] VGND VGND VPWR
+ VPWR _2140_ sky130_fd_sc_hd__clkbuf_1
XFILLER_0_60_226 VGND VGND VPWR VPWR sky130_fd_sc_hd__fill_1
XFILLER_0_26_481 VGND VGND VPWR VPWR sky130_fd_sc_hd__decap_4
X_2768_ _1659_ VGND VGND VPWR VPWR _2076_ sky130_fd_sc_hd__clkbuf_1
XTAP_TAPCELL_ROW_96_1183 VGND VPWR sky130_fd_sc_hd__tapvpwrvgnd_1
XTAP_TAPCELL_ROW_96_1172 VGND VPWR sky130_fd_sc_hd__tapvpwrvgnd_1
X_2699_ _2017_ VGND VGND VPWR VPWR _2018_ sky130_fd_sc_hd__clkbuf_1
XFILLER_0_13_153 VGND VGND VPWR VPWR sky130_fd_sc_hd__fill_2
X_4507_ clknet_leaf_52_clk _0238_ net13 VGND VGND VPWR VPWR tree_instances\[5\].u_tree.pipeline_current_node\[0\]\[7\]
+ sky130_fd_sc_hd__dfrtp_1
X_4438_ clknet_leaf_58_clk _0184_ net12 VGND VGND VPWR VPWR tree_instances\[2\].u_tree.frame_id_out\[2\]
+ sky130_fd_sc_hd__dfrtp_1
X_4369_ clknet_leaf_1_clk _0082_ net9 VGND VGND VPWR VPWR tree_instances\[9\].u_tree.tree_state\[3\]
+ sky130_fd_sc_hd__dfrtp_1
XFILLER_0_83_90 VGND VGND VPWR VPWR sky130_fd_sc_hd__fill_2
XTAP_TAPCELL_ROW_72_928 VGND VPWR sky130_fd_sc_hd__tapvpwrvgnd_1
XFILLER_0_95_167 VGND VGND VPWR VPWR sky130_fd_sc_hd__fill_1
XFILLER_0_95_156 VGND VGND VPWR VPWR sky130_fd_sc_hd__decap_4
XANTENNA__4775__RESET_B net13 VGND VGND VPWR VPWR sky130_fd_sc_hd__diode_2
XFILLER_0_49_573 VGND VGND VPWR VPWR sky130_fd_sc_hd__fill_1
XANTENNA__4704__RESET_B net9 VGND VGND VPWR VPWR sky130_fd_sc_hd__diode_2
XFILLER_0_64_565 VGND VGND VPWR VPWR sky130_fd_sc_hd__decap_8
XFILLER_0_36_256 VGND VGND VPWR VPWR sky130_fd_sc_hd__decap_6
XFILLER_0_47_28 VGND VGND VPWR VPWR sky130_fd_sc_hd__fill_2
XFILLER_0_74_329 VGND VGND VPWR VPWR sky130_fd_sc_hd__fill_2
XTAP_TAPCELL_ROW_43_641 VGND VPWR sky130_fd_sc_hd__tapvpwrvgnd_1
XANTENNA__3667__A tree_instances\[0\].u_tree.frame_id_in\[4\] VGND VGND VPWR VPWR
+ sky130_fd_sc_hd__diode_2
XANTENNA__2571__A _1666_ VGND VGND VPWR VPWR sky130_fd_sc_hd__diode_2
X_3740_ _1023_ _1209_ VGND VGND VPWR VPWR _1212_ sky130_fd_sc_hd__and2_1
XTAP_TAPCELL_ROW_15_354 VGND VPWR sky130_fd_sc_hd__tapvpwrvgnd_1
XANTENNA__4445__RESET_B net9 VGND VGND VPWR VPWR sky130_fd_sc_hd__diode_2
XFILLER_0_27_234 VGND VGND VPWR VPWR sky130_fd_sc_hd__fill_2
XFILLER_0_82_340 VGND VGND VPWR VPWR sky130_fd_sc_hd__fill_2
XFILLER_0_12_42 VGND VGND VPWR VPWR sky130_fd_sc_hd__decap_8
XFILLER_0_27_278 VGND VGND VPWR VPWR sky130_fd_sc_hd__fill_2
XFILLER_0_70_524 VGND VGND VPWR VPWR sky130_fd_sc_hd__decap_8
XFILLER_0_12_64 VGND VGND VPWR VPWR sky130_fd_sc_hd__fill_1
X_3671_ _1170_ VGND VGND VPWR VPWR _0288_ sky130_fd_sc_hd__clkbuf_1
X_2622_ _1949_ VGND VGND VPWR VPWR _1950_ sky130_fd_sc_hd__clkbuf_1
XANTENNA_clkbuf_leaf_71_clk_A clknet_3_0__leaf_clk VGND VGND VPWR VPWR sky130_fd_sc_hd__diode_2
X_2553_ tree_instances\[2\].u_tree.tree_state\[0\] _1890_ _1891_ VGND VGND VPWR VPWR
+ _0067_ sky130_fd_sc_hd__a21o_1
X_2484_ tree_instances\[0\].u_tree.tree_state\[3\] VGND VGND VPWR VPWR _1832_ sky130_fd_sc_hd__buf_2
X_4223_ tree_instances\[18\].u_tree.frame_id_out\[0\] tree_instances\[18\].u_tree.pipeline_frame_id\[0\]\[0\]
+ _1670_ VGND VGND VPWR VPWR _1493_ sky130_fd_sc_hd__mux2_1
X_4154_ _1454_ VGND VGND VPWR VPWR _1455_ sky130_fd_sc_hd__clkbuf_1
XFILLER_0_37_50 VGND VGND VPWR VPWR sky130_fd_sc_hd__fill_2
X_3105_ tree_instances\[0\].u_tree.frame_id_out\[2\] VGND VGND VPWR VPWR _0777_ sky130_fd_sc_hd__inv_2
X_4085_ _1405_ VGND VGND VPWR VPWR _0467_ sky130_fd_sc_hd__clkbuf_1
X_3036_ _0646_ tree_instances\[7\].u_tree.frame_id_out\[0\] tree_instances\[7\].u_tree.frame_id_out\[1\]
+ _0685_ VGND VGND VPWR VPWR _0708_ sky130_fd_sc_hd__o2bb2a_1
XFILLER_0_92_104 VGND VGND VPWR VPWR sky130_fd_sc_hd__fill_1
XANTENNA_clkbuf_leaf_24_clk_A clknet_3_3__leaf_clk VGND VGND VPWR VPWR sky130_fd_sc_hd__diode_2
XFILLER_0_58_392 VGND VGND VPWR VPWR sky130_fd_sc_hd__decap_8
XFILLER_0_18_234 VPWR VGND VPWR VGND sky130_ef_sc_hd__decap_12
XANTENNA__2481__A _1827_ VGND VGND VPWR VPWR sky130_fd_sc_hd__diode_2
XANTENNA__4172__S _0018_ VGND VGND VPWR VPWR sky130_fd_sc_hd__diode_2
X_3938_ tree_instances\[15\].u_tree.pipeline_current_node\[0\]\[7\] VGND VGND VPWR
+ VPWR _1328_ sky130_fd_sc_hd__clkbuf_1
X_3869_ _1278_ VGND VGND VPWR VPWR _1279_ sky130_fd_sc_hd__clkbuf_1
XFILLER_0_61_546 VGND VGND VPWR VPWR sky130_fd_sc_hd__decap_4
XFILLER_0_61_513 VGND VGND VPWR VPWR sky130_fd_sc_hd__fill_2
XFILLER_0_33_237 VGND VGND VPWR VPWR sky130_fd_sc_hd__fill_2
XANTENNA_clkbuf_leaf_39_clk_A clknet_3_7__leaf_clk VGND VGND VPWR VPWR sky130_fd_sc_hd__diode_2
XFILLER_0_41_281 VPWR VGND VPWR VGND sky130_ef_sc_hd__decap_12
XFILLER_0_96_421 VPWR VGND VPWR VGND sky130_ef_sc_hd__decap_12
XTAP_TAPCELL_ROW_57_777 VGND VPWR sky130_fd_sc_hd__tapvpwrvgnd_1
XANTENNA__4815__SET_B net10 VGND VGND VPWR VPWR sky130_fd_sc_hd__diode_2
XFILLER_0_49_370 VGND VGND VPWR VPWR sky130_fd_sc_hd__fill_2
XFILLER_0_56_318 VGND VGND VPWR VPWR sky130_fd_sc_hd__fill_2
XTAP_TAPCELL_ROW_40_611 VGND VPWR sky130_fd_sc_hd__tapvpwrvgnd_1
XTAP_TAPCELL_ROW_12_324 VGND VPWR sky130_fd_sc_hd__tapvpwrvgnd_1
XFILLER_0_91_181 VPWR VGND VPWR VGND sky130_ef_sc_hd__decap_12
XFILLER_0_52_557 VPWR VGND VPWR VGND sky130_ef_sc_hd__decap_12
XFILLER_0_58_27 VGND VGND VPWR VPWR sky130_fd_sc_hd__fill_1
XFILLER_0_20_421 VGND VGND VPWR VPWR sky130_fd_sc_hd__decap_4
XANTENNA__4697__RESET_B net9 VGND VGND VPWR VPWR sky130_fd_sc_hd__diode_2
XANTENNA__4626__RESET_B net9 VGND VGND VPWR VPWR sky130_fd_sc_hd__diode_2
XFILLER_0_90_58 VPWR VGND VPWR VGND sky130_ef_sc_hd__decap_12
XFILLER_0_90_47 VGND VGND VPWR VPWR sky130_fd_sc_hd__fill_1
XTAP_TAPCELL_ROW_82_1024 VGND VPWR sky130_fd_sc_hd__tapvpwrvgnd_1
XTAP_TAPCELL_ROW_28_490 VGND VPWR sky130_fd_sc_hd__tapvpwrvgnd_1
X_4841_ clknet_leaf_49_clk _0523_ net10 VGND VGND VPWR VPWR tree_instances\[18\].u_tree.ready_for_next
+ sky130_fd_sc_hd__dfstp_1
XFILLER_0_47_307 VGND VGND VPWR VPWR sky130_fd_sc_hd__decap_8
XFILLER_0_74_126 VGND VGND VPWR VPWR sky130_fd_sc_hd__fill_2
XFILLER_0_28_554 VPWR VGND VPWR VGND sky130_ef_sc_hd__decap_12
X_4772_ clknet_leaf_49_clk _0055_ net10 VGND VGND VPWR VPWR tree_instances\[15\].u_tree.tree_state\[3\]
+ sky130_fd_sc_hd__dfrtp_1
X_3723_ tree_instances\[8\].u_tree.frame_id_out\[4\] tree_instances\[8\].u_tree.pipeline_frame_id\[0\]\[4\]
+ tree_instances\[8\].u_tree.tree_state\[3\] VGND VGND VPWR VPWR _1199_ sky130_fd_sc_hd__mux2_1
XFILLER_0_70_354 VGND VGND VPWR VPWR sky130_fd_sc_hd__fill_2
X_3654_ _1160_ VGND VGND VPWR VPWR _0281_ sky130_fd_sc_hd__clkbuf_1
XFILLER_0_43_546 VGND VGND VPWR VPWR sky130_fd_sc_hd__fill_1
XFILLER_0_70_365 VGND VGND VPWR VPWR sky130_fd_sc_hd__decap_3
X_2605_ _1666_ tree_instances\[15\].u_tree.pipeline_valid\[0\] VGND VGND VPWR VPWR
+ _1935_ sky130_fd_sc_hd__or2_1
X_3585_ _1114_ VGND VGND VPWR VPWR _1115_ sky130_fd_sc_hd__clkbuf_1
XTAP_TAPCELL_ROW_93_1142 VGND VPWR sky130_fd_sc_hd__tapvpwrvgnd_1
XFILLER_0_23_281 VGND VGND VPWR VPWR sky130_fd_sc_hd__decap_4
XFILLER_0_11_443 VGND VGND VPWR VPWR sky130_fd_sc_hd__fill_2
X_2536_ tree_instances\[2\].u_tree.pipeline_current_node\[0\]\[2\] VGND VGND VPWR
+ VPWR _1877_ sky130_fd_sc_hd__clkbuf_1
X_2467_ tree_instances\[4\].u_tree.pipeline_current_node\[0\]\[1\] VGND VGND VPWR
+ VPWR _1818_ sky130_fd_sc_hd__clkbuf_1
XFILLER_0_48_60 VGND VGND VPWR VPWR sky130_fd_sc_hd__fill_1
X_4206_ _1484_ VGND VGND VPWR VPWR _0509_ sky130_fd_sc_hd__clkbuf_1
XFILLER_0_47_3 VGND VGND VPWR VPWR sky130_fd_sc_hd__fill_1
X_2398_ _1754_ _1755_ VGND VGND VPWR VPWR _1756_ sky130_fd_sc_hd__nor2_1
X_4137_ _1176_ VGND VGND VPWR VPWR _1442_ sky130_fd_sc_hd__clkbuf_1
XFILLER_0_64_81 VGND VGND VPWR VPWR sky130_fd_sc_hd__fill_1
X_4068_ _1936_ _0956_ _0642_ tree_instances\[15\].u_tree.ready_for_next VGND VGND
+ VPWR VPWR _0460_ sky130_fd_sc_hd__a22o_1
X_3019_ _0690_ VGND VGND VPWR VPWR _0691_ sky130_fd_sc_hd__clkbuf_4
XANTENNA__4367__RESET_B net9 VGND VGND VPWR VPWR sky130_fd_sc_hd__diode_2
XFILLER_0_38_307 VGND VGND VPWR VPWR sky130_fd_sc_hd__fill_1
XTAP_TAPCELL_ROW_54_747 VGND VPWR sky130_fd_sc_hd__tapvpwrvgnd_1
XFILLER_0_93_446 VGND VGND VPWR VPWR sky130_fd_sc_hd__fill_2
XFILLER_0_80_80 VGND VGND VPWR VPWR sky130_fd_sc_hd__decap_4
XFILLER_0_34_524 VGND VGND VPWR VPWR sky130_fd_sc_hd__fill_1
XFILLER_0_46_362 VGND VGND VPWR VPWR sky130_fd_sc_hd__fill_2
XANTENNA__3050__A1 _0686_ VGND VGND VPWR VPWR sky130_fd_sc_hd__diode_2
XANTENNA__3050__B2 _0697_ VGND VGND VPWR VPWR sky130_fd_sc_hd__diode_2
XFILLER_0_61_343 VGND VGND VPWR VPWR sky130_fd_sc_hd__fill_2
XFILLER_0_61_332 VGND VGND VPWR VPWR sky130_fd_sc_hd__fill_2
XFILLER_0_34_557 VGND VGND VPWR VPWR sky130_fd_sc_hd__fill_2
XFILLER_0_14_281 VGND VGND VPWR VPWR sky130_fd_sc_hd__fill_2
XANTENNA__4302__A1 _0664_ VGND VGND VPWR VPWR sky130_fd_sc_hd__diode_2
XFILLER_0_69_421 VPWR VGND VPWR VGND sky130_ef_sc_hd__decap_12
XANTENNA__4790__RESET_B net13 VGND VGND VPWR VPWR sky130_fd_sc_hd__diode_2
XFILLER_0_44_29 VGND VGND VPWR VPWR sky130_fd_sc_hd__fill_2
XFILLER_0_84_413 VGND VGND VPWR VPWR sky130_fd_sc_hd__decap_6
XFILLER_0_69_487 VGND VGND VPWR VPWR sky130_fd_sc_hd__decap_3
XFILLER_0_69_465 VGND VGND VPWR VPWR sky130_fd_sc_hd__decap_6
XTAP_TAPCELL_ROW_25_460 VGND VPWR sky130_fd_sc_hd__tapvpwrvgnd_1
XFILLER_0_56_137 VGND VGND VPWR VPWR sky130_fd_sc_hd__decap_3
XANTENNA__3010__A _0682_ VGND VGND VPWR VPWR sky130_fd_sc_hd__diode_2
XANTENNA__3041__A1 _0648_ VGND VGND VPWR VPWR sky130_fd_sc_hd__diode_2
XANTENNA__3041__B2 _0691_ VGND VGND VPWR VPWR sky130_fd_sc_hd__diode_2
XFILLER_0_8_29 VPWR VGND VPWR VGND sky130_ef_sc_hd__decap_12
XFILLER_0_52_321 VGND VGND VPWR VPWR sky130_fd_sc_hd__fill_2
XFILLER_0_52_365 VGND VGND VPWR VPWR sky130_fd_sc_hd__decap_4
X_3370_ tree_instances\[2\].u_tree.pipeline_current_node\[0\]\[8\] _0959_ VGND VGND
+ VPWR VPWR _0982_ sky130_fd_sc_hd__and2_1
XFILLER_0_20_251 VGND VGND VPWR VPWR sky130_fd_sc_hd__fill_1
X_2321_ _1685_ _1687_ VGND VGND VPWR VPWR _0077_ sky130_fd_sc_hd__nand2_1
XANTENNA__4878__RESET_B net10 VGND VGND VPWR VPWR sky130_fd_sc_hd__diode_2
X_2252_ tree_instances\[17\].u_tree.tree_state\[2\] _1627_ tree_instances\[17\].u_tree.tree_state\[1\]
+ VGND VGND VPWR VPWR _0059_ sky130_fd_sc_hd__a21o_1
XFILLER_0_85_69 VGND VGND VPWR VPWR sky130_fd_sc_hd__decap_6
XANTENNA__4807__RESET_B net12 VGND VGND VPWR VPWR sky130_fd_sc_hd__diode_2
X_2183_ tree_instances\[12\].u_tree.pipeline_current_node\[0\]\[7\] VGND VGND VPWR
+ VPWR _1566_ sky130_fd_sc_hd__clkbuf_1
XANTENNA__2296__A _1574_ VGND VGND VPWR VPWR sky130_fd_sc_hd__diode_2
XFILLER_0_79_229 VGND VGND VPWR VPWR sky130_fd_sc_hd__decap_6
XANTENNA__4460__RESET_B net9 VGND VGND VPWR VPWR sky130_fd_sc_hd__diode_2
XFILLER_0_47_104 VGND VGND VPWR VPWR sky130_fd_sc_hd__fill_1
XTAP_TAPCELL_ROW_51_717 VGND VPWR sky130_fd_sc_hd__tapvpwrvgnd_1
X_4824_ clknet_leaf_50_clk _0506_ net10 VGND VGND VPWR VPWR tree_instances\[18\].u_tree.pipeline_current_node\[0\]\[2\]
+ sky130_fd_sc_hd__dfrtp_1
X_4755_ clknet_leaf_49_clk _0452_ net10 VGND VGND VPWR VPWR tree_instances\[15\].u_tree.pipeline_frame_id\[0\]\[2\]
+ sky130_fd_sc_hd__dfrtp_1
X_3706_ tree_instances\[8\].u_tree.pipeline_frame_id\[0\]\[1\] _1124_ _0040_ VGND
+ VGND VPWR VPWR _1190_ sky130_fd_sc_hd__mux2_1
XFILLER_0_16_557 VPWR VGND VPWR VGND sky130_ef_sc_hd__decap_12
XFILLER_0_43_332 VGND VGND VPWR VPWR sky130_fd_sc_hd__fill_2
X_4686_ clknet_leaf_14_clk _0390_ net12 VGND VGND VPWR VPWR tree_instances\[12\].u_tree.pipeline_frame_id\[0\]\[3\]
+ sky130_fd_sc_hd__dfrtp_1
XFILLER_0_70_151 VPWR VGND VPWR VGND sky130_ef_sc_hd__decap_12
XFILLER_0_31_505 VGND VGND VPWR VPWR sky130_fd_sc_hd__fill_2
XFILLER_0_70_195 VGND VGND VPWR VPWR sky130_fd_sc_hd__fill_1
X_3637_ _1675_ VGND VGND VPWR VPWR _1148_ sky130_fd_sc_hd__clkbuf_1
X_3568_ _1101_ VGND VGND VPWR VPWR _0254_ sky130_fd_sc_hd__clkbuf_1
XFILLER_0_3_473 VPWR VGND VPWR VGND sky130_ef_sc_hd__decap_12
X_2519_ _1720_ VGND VGND VPWR VPWR _1864_ sky130_fd_sc_hd__clkbuf_1
X_3499_ _1055_ VGND VGND VPWR VPWR _0231_ sky130_fd_sc_hd__clkbuf_1
XANTENNA__4548__RESET_B net13 VGND VGND VPWR VPWR sky130_fd_sc_hd__diode_2
XANTENNA__3099__A1 _0686_ VGND VGND VPWR VPWR sky130_fd_sc_hd__diode_2
XTAP_TAPCELL_ROW_67_883 VGND VPWR sky130_fd_sc_hd__tapvpwrvgnd_1
XTAP_TAPCELL_ROW_39_596 VGND VPWR sky130_fd_sc_hd__tapvpwrvgnd_1
XANTENNA__3271__A1 _0673_ VGND VGND VPWR VPWR sky130_fd_sc_hd__diode_2
XFILLER_0_78_284 VGND VGND VPWR VPWR sky130_fd_sc_hd__fill_2
XFILLER_0_78_273 VGND VGND VPWR VPWR sky130_fd_sc_hd__fill_2
XFILLER_0_93_276 VGND VGND VPWR VPWR sky130_fd_sc_hd__fill_1
XANTENNA__4646__SET_B net9 VGND VGND VPWR VPWR sky130_fd_sc_hd__diode_2
XFILLER_0_19_373 VGND VGND VPWR VPWR sky130_fd_sc_hd__decap_3
XTAP_TAPCELL_ROW_22_430 VGND VPWR sky130_fd_sc_hd__tapvpwrvgnd_1
XFILLER_0_53_129 VGND VGND VPWR VPWR sky130_fd_sc_hd__fill_2
XFILLER_0_81_449 VPWR VGND VPWR VGND sky130_ef_sc_hd__decap_12
XFILLER_0_39_29 VPWR VGND VPWR VGND sky130_ef_sc_hd__decap_12
XFILLER_0_89_505 VGND VGND VPWR VPWR sky130_fd_sc_hd__decap_6
XANTENNA__3005__A _0678_ VGND VGND VPWR VPWR sky130_fd_sc_hd__diode_2
XFILLER_0_71_27 VPWR VGND VPWR VGND sky130_ef_sc_hd__decap_12
XFILLER_0_29_137 VGND VGND VPWR VPWR sky130_fd_sc_hd__decap_6
X_2870_ _0570_ VGND VGND VPWR VPWR _0577_ sky130_fd_sc_hd__clkbuf_1
XFILLER_0_65_490 VPWR VGND VPWR VGND sky130_ef_sc_hd__decap_12
XFILLER_0_25_332 VGND VGND VPWR VPWR sky130_fd_sc_hd__fill_2
XFILLER_0_37_181 VGND VGND VPWR VPWR sky130_fd_sc_hd__fill_1
X_4540_ clknet_leaf_19_clk _0270_ net11 VGND VGND VPWR VPWR tree_instances\[6\].u_tree.frame_id_out\[3\]
+ sky130_fd_sc_hd__dfrtp_1
XFILLER_0_13_505 VPWR VGND VPWR VGND sky130_ef_sc_hd__decap_12
Xclkbuf_leaf_10_clk clknet_3_2__leaf_clk VGND VGND VPWR VPWR clknet_leaf_10_clk sky130_fd_sc_hd__clkbuf_4
X_4471_ clknet_leaf_65_clk _0211_ tree_instances\[0\].u_tree.rst_n VGND VGND VPWR
+ VPWR tree_instances\[4\].u_tree.pipeline_current_node\[0\]\[1\] sky130_fd_sc_hd__dfrtp_1
XFILLER_0_52_173 VGND VGND VPWR VPWR sky130_fd_sc_hd__decap_3
XFILLER_0_0_421 VPWR VGND VPWR VGND sky130_ef_sc_hd__decap_12
X_3422_ tree_instances\[3\].u_tree.pipeline_frame_id\[0\]\[3\] _0925_ _0030_ VGND
+ VGND VPWR VPWR _1009_ sky130_fd_sc_hd__mux2_1
XFILLER_0_40_357 VGND VGND VPWR VPWR sky130_fd_sc_hd__decap_4
XFILLER_0_96_57 VPWR VGND VPWR VGND sky130_ef_sc_hd__decap_12
XTAP_TAPCELL_ROW_90_1112 VGND VPWR sky130_fd_sc_hd__tapvpwrvgnd_1
X_3353_ _0969_ VGND VGND VPWR VPWR _0970_ sky130_fd_sc_hd__clkbuf_1
X_3284_ tree_instances\[0\].u_tree.frame_id_out\[2\] tree_instances\[0\].u_tree.pipeline_frame_id\[0\]\[2\]
+ _1832_ VGND VGND VPWR VPWR _0930_ sky130_fd_sc_hd__mux2_1
X_2304_ tree_instances\[7\].u_tree.pipeline_current_node\[0\]\[1\] tree_instances\[7\].u_tree.pipeline_current_node\[0\]\[2\]
+ VGND VGND VPWR VPWR _1672_ sky130_fd_sc_hd__or2_1
X_2235_ tree_instances\[11\].u_tree.pipeline_current_node\[0\]\[6\] tree_instances\[11\].u_tree.pipeline_current_node\[0\]\[7\]
+ VGND VGND VPWR VPWR _1612_ sky130_fd_sc_hd__nor2_1
XANTENNA__4641__RESET_B tree_instances\[0\].u_tree.rst_n VGND VGND VPWR VPWR sky130_fd_sc_hd__diode_2
X_2166_ tree_instances\[11\].u_tree.ready_for_next tree_instances\[10\].u_tree.ready_for_next
+ tree_instances\[13\].u_tree.ready_for_next tree_instances\[12\].u_tree.ready_for_next
+ VGND VGND VPWR VPWR _1550_ sky130_fd_sc_hd__and4_1
XTAP_TAPCELL_ROW_88_1085 VGND VPWR sky130_fd_sc_hd__tapvpwrvgnd_1
XTAP_TAPCELL_ROW_64_853 VGND VPWR sky130_fd_sc_hd__tapvpwrvgnd_1
XFILLER_0_0_41 VPWR VGND VPWR VGND sky130_ef_sc_hd__decap_12
XTAP_TAPCELL_ROW_36_566 VGND VPWR sky130_fd_sc_hd__tapvpwrvgnd_1
XFILLER_0_75_243 VGND VGND VPWR VPWR sky130_fd_sc_hd__fill_1
XFILLER_0_0_85 VPWR VGND VPWR VGND sky130_ef_sc_hd__decap_12
XFILLER_0_90_213 VPWR VGND VPWR VGND sky130_ef_sc_hd__decap_12
XFILLER_0_75_265 VPWR VGND VPWR VGND sky130_ef_sc_hd__decap_12
XFILLER_0_63_438 VGND VGND VPWR VPWR sky130_fd_sc_hd__decap_8
XPHY_EDGE_ROW_3_Right_3 VGND VGND VPWR VPWR sky130_fd_sc_hd__decap_3
X_4807_ clknet_leaf_60_clk _0494_ net12 VGND VGND VPWR VPWR tree_instances\[17\].u_tree.pipeline_frame_id\[0\]\[2\]
+ sky130_fd_sc_hd__dfrtp_1
XFILLER_0_90_246 VGND VGND VPWR VPWR sky130_fd_sc_hd__decap_6
X_2999_ tree_instances\[0\].u_tree.frame_id_in\[2\] VGND VGND VPWR VPWR _0674_ sky130_fd_sc_hd__buf_2
XFILLER_0_63_449 VPWR VGND VPWR VGND sky130_ef_sc_hd__decap_12
XANTENNA__4180__S _1827_ VGND VGND VPWR VPWR sky130_fd_sc_hd__diode_2
X_4738_ clknet_leaf_25_clk _0436_ net11 VGND VGND VPWR VPWR tree_instances\[14\].u_tree.frame_id_out\[2\]
+ sky130_fd_sc_hd__dfrtp_1
XFILLER_0_16_365 VPWR VGND VPWR VGND sky130_ef_sc_hd__decap_12
XFILLER_0_71_493 VGND VGND VPWR VPWR sky130_fd_sc_hd__fill_2
X_4669_ clknet_leaf_10_clk _0374_ tree_instances\[0\].u_tree.rst_n VGND VGND VPWR
+ VPWR tree_instances\[11\].u_tree.frame_id_out\[3\] sky130_fd_sc_hd__dfrtp_1
XFILLER_0_31_368 VGND VGND VPWR VPWR sky130_fd_sc_hd__fill_2
XANTENNA__4729__RESET_B net10 VGND VGND VPWR VPWR sky130_fd_sc_hd__diode_2
XFILLER_0_86_90 VPWR VGND VPWR VGND sky130_ef_sc_hd__decap_12
XANTENNA__4382__RESET_B net10 VGND VGND VPWR VPWR sky130_fd_sc_hd__diode_2
Xclkbuf_leaf_68_clk clknet_3_0__leaf_clk VGND VGND VPWR VPWR clknet_leaf_68_clk sky130_fd_sc_hd__clkbuf_4
XFILLER_0_19_181 VGND VGND VPWR VPWR sky130_fd_sc_hd__decap_6
XFILLER_0_34_195 VGND VGND VPWR VPWR sky130_fd_sc_hd__fill_1
XANTENNA__4341__SET_B tree_instances\[0\].u_tree.rst_n VGND VGND VPWR VPWR sky130_fd_sc_hd__diode_2
XFILLER_0_66_49 VGND VGND VPWR VPWR sky130_fd_sc_hd__decap_3
XTAP_TAPCELL_ROW_7_280 VGND VPWR sky130_fd_sc_hd__tapvpwrvgnd_1
XTAP_TAPCELL_ROW_78_989 VGND VPWR sky130_fd_sc_hd__tapvpwrvgnd_1
Xclkbuf_leaf_59_clk clknet_3_4__leaf_clk VGND VGND VPWR VPWR clknet_leaf_59_clk sky130_fd_sc_hd__clkbuf_4
XFILLER_0_89_335 VGND VGND VPWR VPWR sky130_fd_sc_hd__fill_1
XFILLER_0_15_31 VGND VGND VPWR VPWR sky130_fd_sc_hd__fill_2
XFILLER_0_85_530 VPWR VGND VPWR VGND sky130_ef_sc_hd__decap_12
X_3971_ _1346_ VGND VGND VPWR VPWR _0412_ sky130_fd_sc_hd__clkbuf_1
X_2922_ tree_instances\[6\].u_tree.tree_state\[0\] VGND VGND VPWR VPWR _0619_ sky130_fd_sc_hd__inv_2
XTAP_TAPCELL_ROW_61_823 VGND VPWR sky130_fd_sc_hd__tapvpwrvgnd_1
XFILLER_0_57_254 VGND VGND VPWR VPWR sky130_fd_sc_hd__fill_2
XTAP_TAPCELL_ROW_33_536 VGND VPWR sky130_fd_sc_hd__tapvpwrvgnd_1
XFILLER_0_45_405 VGND VGND VPWR VPWR sky130_fd_sc_hd__fill_2
XFILLER_0_45_427 VGND VGND VPWR VPWR sky130_fd_sc_hd__fill_2
X_2853_ _1915_ VGND VGND VPWR VPWR _2155_ sky130_fd_sc_hd__clkbuf_1
XFILLER_0_38_490 VPWR VGND VPWR VGND sky130_ef_sc_hd__decap_12
XFILLER_0_45_449 VPWR VGND VPWR VGND sky130_ef_sc_hd__decap_12
XFILLER_0_25_151 VGND VGND VPWR VPWR sky130_fd_sc_hd__decap_3
XFILLER_0_31_63 VPWR VGND VPWR VGND sky130_ef_sc_hd__decap_12
X_2784_ tree_instances\[16\].u_tree.prediction_valid _1729_ VGND VGND VPWR VPWR _2090_
+ sky130_fd_sc_hd__and2b_1
X_4523_ clknet_leaf_18_clk _0253_ net11 VGND VGND VPWR VPWR tree_instances\[6\].u_tree.pipeline_current_node\[0\]\[0\]
+ sky130_fd_sc_hd__dfrtp_1
XFILLER_0_13_335 VGND VGND VPWR VPWR sky130_fd_sc_hd__fill_1
XFILLER_0_25_173 VGND VGND VPWR VPWR sky130_fd_sc_hd__decap_8
XANTENNA__4893__RESET_B net10 VGND VGND VPWR VPWR sky130_fd_sc_hd__diode_2
XFILLER_0_40_121 VPWR VGND VPWR VGND sky130_ef_sc_hd__decap_12
X_4454_ clknet_leaf_68_clk _0195_ net9 VGND VGND VPWR VPWR tree_instances\[3\].u_tree.pipeline_current_node\[0\]\[6\]
+ sky130_fd_sc_hd__dfrtp_1
XANTENNA__4822__RESET_B net10 VGND VGND VPWR VPWR sky130_fd_sc_hd__diode_2
X_4385_ clknet_leaf_36_clk _0133_ net10 VGND VGND VPWR VPWR tree_instances\[0\].u_tree.pipeline_current_node\[0\]\[7\]
+ sky130_fd_sc_hd__dfrtp_1
X_3405_ _1000_ VGND VGND VPWR VPWR _0192_ sky130_fd_sc_hd__clkbuf_1
XTAP_TAPCELL_ROW_69_901 VGND VPWR sky130_fd_sc_hd__tapvpwrvgnd_1
X_3336_ _1936_ _0956_ _0014_ tree_instances\[15\].u_tree.pipeline_valid\[0\] VGND
+ VGND VPWR VPWR _0167_ sky130_fd_sc_hd__o2bb2a_1
X_3267_ _2132_ _0911_ VGND VGND VPWR VPWR _0921_ sky130_fd_sc_hd__and2_1
XANTENNA__3474__A1 _0675_ VGND VGND VPWR VPWR sky130_fd_sc_hd__diode_2
X_3198_ _0726_ _0867_ _0868_ _0869_ tree_instances\[13\].u_tree.prediction_valid VGND
+ VGND VPWR VPWR _0870_ sky130_fd_sc_hd__o221a_1
X_2218_ _1575_ tree_instances\[10\].u_tree.pipeline_valid\[0\] VGND VGND VPWR VPWR
+ _1596_ sky130_fd_sc_hd__or2_1
XFILLER_0_95_349 VPWR VGND VPWR VGND sky130_ef_sc_hd__decap_12
XFILLER_0_95_327 VGND VGND VPWR VPWR sky130_fd_sc_hd__fill_1
XANTENNA__2985__A0 _0662_ VGND VGND VPWR VPWR sky130_fd_sc_hd__diode_2
XFILLER_0_91_544 VPWR VGND VPWR VGND sky130_ef_sc_hd__decap_12
XFILLER_0_8_362 VGND VGND VPWR VPWR sky130_fd_sc_hd__fill_2
XFILLER_0_8_384 VGND VGND VPWR VPWR sky130_fd_sc_hd__fill_1
XPHY_EDGE_ROW_15_Left_112 VGND VGND VPWR VPWR sky130_fd_sc_hd__decap_3
XFILLER_0_16_195 VGND VGND VPWR VPWR sky130_fd_sc_hd__fill_1
XANTENNA__4563__RESET_B tree_instances\[0\].u_tree.rst_n VGND VGND VPWR VPWR sky130_fd_sc_hd__diode_2
XFILLER_0_31_198 VGND VGND VPWR VPWR sky130_fd_sc_hd__decap_3
XTAP_TAPCELL_ROW_4_250 VGND VPWR sky130_fd_sc_hd__tapvpwrvgnd_1
XPHY_EDGE_ROW_24_Left_121 VGND VGND VPWR VPWR sky130_fd_sc_hd__decap_3
XTAP_TAPCELL_ROW_75_959 VGND VPWR sky130_fd_sc_hd__tapvpwrvgnd_1
XANTENNA__2976__A0 _0655_ VGND VGND VPWR VPWR sky130_fd_sc_hd__diode_2
XFILLER_0_39_287 VGND VGND VPWR VPWR sky130_fd_sc_hd__fill_1
XFILLER_0_82_533 VPWR VGND VPWR VGND sky130_ef_sc_hd__decap_12
XFILLER_0_27_449 VPWR VGND VPWR VGND sky130_ef_sc_hd__decap_12
XTAP_TAPCELL_ROW_30_506 VGND VPWR sky130_fd_sc_hd__tapvpwrvgnd_1
XPHY_EDGE_ROW_33_Left_130 VGND VGND VPWR VPWR sky130_fd_sc_hd__decap_3
XFILLER_0_54_257 VGND VGND VPWR VPWR sky130_fd_sc_hd__fill_1
XANTENNA__4765__SET_B net10 VGND VGND VPWR VPWR sky130_fd_sc_hd__diode_2
XFILLER_0_50_430 VPWR VGND VPWR VGND sky130_ef_sc_hd__decap_12
XFILLER_0_77_15 VGND VGND VPWR VPWR sky130_fd_sc_hd__decap_6
XFILLER_0_50_474 VGND VGND VPWR VPWR sky130_fd_sc_hd__fill_2
XFILLER_0_77_48 VGND VGND VPWR VPWR sky130_fd_sc_hd__fill_2
X_4170_ tree_instances\[17\].u_tree.pipeline_frame_id\[0\]\[0\] _0664_ _0018_ VGND
+ VGND VPWR VPWR _1466_ sky130_fd_sc_hd__mux2_1
X_3121_ _0661_ tree_instances\[2\].u_tree.frame_id_out\[4\] VGND VGND VPWR VPWR _0793_
+ sky130_fd_sc_hd__xnor2_1
XFILLER_0_26_41 VPWR VGND VPWR VGND sky130_ef_sc_hd__decap_12
X_3052_ _0714_ tree_instances\[15\].u_tree.frame_id_out\[2\] tree_instances\[15\].u_tree.prediction_valid
+ VGND VGND VPWR VPWR _0724_ sky130_fd_sc_hd__o21ai_1
XTAP_TAPCELL_ROW_85_1055 VGND VPWR sky130_fd_sc_hd__tapvpwrvgnd_1
XFILLER_0_77_349 VGND VGND VPWR VPWR sky130_fd_sc_hd__fill_1
XTAP_TAPCELL_ROW_18_385 VGND VPWR sky130_fd_sc_hd__tapvpwrvgnd_1
XTAP_TAPCELL_ROW_46_672 VGND VPWR sky130_fd_sc_hd__tapvpwrvgnd_1
XFILLER_0_73_500 VGND VGND VPWR VPWR sky130_fd_sc_hd__fill_2
X_3954_ _1998_ _1332_ VGND VGND VPWR VPWR _1338_ sky130_fd_sc_hd__and2_1
X_3885_ _2019_ _1294_ VGND VGND VPWR VPWR _1295_ sky130_fd_sc_hd__and2_1
XFILLER_0_85_393 VGND VGND VPWR VPWR sky130_fd_sc_hd__decap_8
XFILLER_0_85_382 VGND VGND VPWR VPWR sky130_fd_sc_hd__fill_1
XFILLER_0_73_544 VPWR VGND VPWR VGND sky130_ef_sc_hd__decap_12
X_2905_ _0607_ _1594_ VGND VGND VPWR VPWR _0608_ sky130_fd_sc_hd__or2_1
X_2836_ _2138_ VGND VGND VPWR VPWR _2139_ sky130_fd_sc_hd__clkbuf_1
XFILLER_0_73_566 VGND VGND VPWR VPWR sky130_fd_sc_hd__decap_8
XFILLER_0_45_279 VGND VGND VPWR VPWR sky130_fd_sc_hd__fill_1
X_2767_ _2074_ VGND VGND VPWR VPWR _2075_ sky130_fd_sc_hd__clkbuf_1
XFILLER_0_13_110 VGND VGND VPWR VPWR sky130_fd_sc_hd__fill_2
XTAP_TAPCELL_ROW_96_1173 VGND VPWR sky130_fd_sc_hd__tapvpwrvgnd_1
X_2698_ _1755_ VGND VGND VPWR VPWR _2017_ sky130_fd_sc_hd__clkbuf_1
XFILLER_0_77_3 VPWR VGND VPWR VGND sky130_ef_sc_hd__decap_12
X_4506_ clknet_leaf_51_clk _0237_ net13 VGND VGND VPWR VPWR tree_instances\[5\].u_tree.pipeline_current_node\[0\]\[6\]
+ sky130_fd_sc_hd__dfrtp_1
X_4437_ clknet_leaf_57_clk _0183_ net13 VGND VGND VPWR VPWR tree_instances\[2\].u_tree.frame_id_out\[1\]
+ sky130_fd_sc_hd__dfrtp_1
XANTENNA__2479__A _1575_ VGND VGND VPWR VPWR sky130_fd_sc_hd__diode_2
X_4368_ clknet_leaf_1_clk _0042_ net9 VGND VGND VPWR VPWR tree_instances\[9\].u_tree.tree_state\[2\]
+ sky130_fd_sc_hd__dfrtp_1
X_3319_ _0948_ VGND VGND VPWR VPWR _0158_ sky130_fd_sc_hd__clkbuf_1
X_4299_ _1532_ VGND VGND VPWR VPWR _0554_ sky130_fd_sc_hd__clkbuf_1
XFILLER_0_68_305 VGND VGND VPWR VPWR sky130_fd_sc_hd__decap_3
XTAP_TAPCELL_ROW_1_220 VGND VPWR sky130_fd_sc_hd__tapvpwrvgnd_1
XFILLER_0_95_113 VGND VGND VPWR VPWR sky130_fd_sc_hd__decap_3
XANTENNA__3103__A _0733_ VGND VGND VPWR VPWR sky130_fd_sc_hd__diode_2
XTAP_TAPCELL_ROW_72_929 VGND VPWR sky130_fd_sc_hd__tapvpwrvgnd_1
XFILLER_0_91_330 VGND VGND VPWR VPWR sky130_fd_sc_hd__decap_3
XFILLER_0_64_533 VGND VGND VPWR VPWR sky130_fd_sc_hd__decap_6
XFILLER_0_91_341 VPWR VGND VPWR VGND sky130_ef_sc_hd__decap_12
XFILLER_0_36_268 VPWR VGND VPWR VGND sky130_ef_sc_hd__decap_12
XANTENNA__4744__RESET_B net10 VGND VGND VPWR VPWR sky130_fd_sc_hd__diode_2
XFILLER_0_51_249 VPWR VGND VPWR VGND sky130_ef_sc_hd__decap_12
XFILLER_0_86_102 VPWR VGND VPWR VGND sky130_ef_sc_hd__decap_12
XFILLER_0_59_327 VGND VGND VPWR VPWR sky130_fd_sc_hd__decap_6
XFILLER_0_74_319 VGND VGND VPWR VPWR sky130_fd_sc_hd__fill_2
XFILLER_0_67_360 VGND VGND VPWR VPWR sky130_fd_sc_hd__fill_2
XTAP_TAPCELL_ROW_43_642 VGND VPWR sky130_fd_sc_hd__tapvpwrvgnd_1
XFILLER_0_67_382 VGND VGND VPWR VPWR sky130_fd_sc_hd__decap_6
XTAP_TAPCELL_ROW_15_355 VGND VPWR sky130_fd_sc_hd__tapvpwrvgnd_1
XFILLER_0_27_246 VGND VGND VPWR VPWR sky130_fd_sc_hd__decap_3
X_3670_ tree_instances\[7\].u_tree.frame_id_out\[0\] tree_instances\[7\].u_tree.pipeline_frame_id\[0\]\[0\]
+ tree_instances\[7\].u_tree.tree_state\[3\] VGND VGND VPWR VPWR _1170_ sky130_fd_sc_hd__mux2_1
XANTENNA__4485__RESET_B tree_instances\[0\].u_tree.rst_n VGND VGND VPWR VPWR sky130_fd_sc_hd__diode_2
X_2621_ _1948_ VGND VGND VPWR VPWR _1949_ sky130_fd_sc_hd__clkbuf_1
XANTENNA__4414__RESET_B net11 VGND VGND VPWR VPWR sky130_fd_sc_hd__diode_2
X_2552_ tree_instances\[2\].u_tree.tree_state\[3\] VGND VGND VPWR VPWR _1891_ sky130_fd_sc_hd__buf_2
XFILLER_0_2_368 VGND VGND VPWR VPWR sky130_fd_sc_hd__fill_1
XFILLER_0_23_496 VGND VGND VPWR VPWR sky130_fd_sc_hd__decap_8
X_2483_ _1574_ tree_instances\[0\].u_tree.pipeline_valid\[0\] VGND VGND VPWR VPWR
+ _1831_ sky130_fd_sc_hd__or2_1
X_4222_ _1492_ VGND VGND VPWR VPWR _0517_ sky130_fd_sc_hd__clkbuf_1
X_4153_ tree_instances\[17\].u_tree.pipeline_current_node\[0\]\[4\] VGND VGND VPWR
+ VPWR _1454_ sky130_fd_sc_hd__clkbuf_1
X_3104_ tree_instances\[0\].u_tree.frame_id_out\[0\] _0694_ _0662_ _0773_ _0775_ VGND
+ VGND VPWR VPWR _0776_ sky130_fd_sc_hd__a221o_1
X_4084_ _2058_ _1399_ VGND VGND VPWR VPWR _1405_ sky130_fd_sc_hd__and2_1
X_3035_ tree_instances\[7\].u_tree.frame_id_out\[1\] VGND VGND VPWR VPWR _0707_ sky130_fd_sc_hd__inv_2
XFILLER_0_77_146 VGND VGND VPWR VPWR sky130_fd_sc_hd__fill_1
XFILLER_0_65_308 VGND VGND VPWR VPWR sky130_fd_sc_hd__fill_2
XFILLER_0_58_360 VGND VGND VPWR VPWR sky130_fd_sc_hd__fill_2
X_3937_ _1317_ VGND VGND VPWR VPWR _1327_ sky130_fd_sc_hd__clkbuf_1
XFILLER_0_46_533 VPWR VGND VPWR VGND sky130_ef_sc_hd__decap_12
XFILLER_0_18_246 VGND VGND VPWR VPWR sky130_fd_sc_hd__decap_6
XFILLER_0_18_257 VPWR VGND VPWR VGND sky130_ef_sc_hd__decap_12
XFILLER_0_46_566 VGND VGND VPWR VPWR sky130_fd_sc_hd__decap_8
X_3868_ tree_instances\[14\].u_tree.pipeline_current_node\[0\]\[3\] VGND VGND VPWR
+ VPWR _1278_ sky130_fd_sc_hd__clkbuf_1
XFILLER_0_33_205 VGND VGND VPWR VPWR sky130_fd_sc_hd__fill_2
XFILLER_0_61_558 VGND VGND VPWR VPWR sky130_fd_sc_hd__fill_2
X_2819_ tree_instances\[3\].u_tree.pipeline_current_node\[0\]\[7\] VGND VGND VPWR
+ VPWR _2123_ sky130_fd_sc_hd__clkbuf_1
X_3799_ _1242_ VGND VGND VPWR VPWR _0344_ sky130_fd_sc_hd__clkbuf_1
XFILLER_0_41_293 VPWR VGND VPWR VGND sky130_ef_sc_hd__decap_12
XANTENNA__3668__A1 _1168_ VGND VGND VPWR VPWR sky130_fd_sc_hd__diode_2
XTAP_TAPCELL_ROW_57_778 VGND VPWR sky130_fd_sc_hd__tapvpwrvgnd_1
XFILLER_0_96_433 VPWR VGND VPWR VGND sky130_ef_sc_hd__decap_12
XFILLER_0_96_477 VPWR VGND VPWR VGND sky130_ef_sc_hd__decap_12
XFILLER_0_49_393 VPWR VGND VPWR VGND sky130_ef_sc_hd__decap_12
XTAP_TAPCELL_ROW_12_325 VGND VPWR sky130_fd_sc_hd__tapvpwrvgnd_1
XTAP_TAPCELL_ROW_40_612 VGND VPWR sky130_fd_sc_hd__tapvpwrvgnd_1
XFILLER_0_91_193 VPWR VGND VPWR VGND sky130_ef_sc_hd__decap_12
XFILLER_0_52_569 VGND VGND VPWR VPWR sky130_fd_sc_hd__decap_4
XFILLER_0_59_113 VGND VGND VPWR VPWR sky130_fd_sc_hd__fill_2
XFILLER_0_59_102 VGND VGND VPWR VPWR sky130_fd_sc_hd__fill_2
XTAP_TAPCELL_ROW_82_1025 VGND VPWR sky130_fd_sc_hd__tapvpwrvgnd_1
XTAP_TAPCELL_ROW_28_491 VGND VPWR sky130_fd_sc_hd__tapvpwrvgnd_1
X_4840_ clknet_leaf_48_clk _0522_ net10 VGND VGND VPWR VPWR tree_instances\[18\].u_tree.frame_id_out\[4\]
+ sky130_fd_sc_hd__dfrtp_1
XFILLER_0_74_138 VGND VGND VPWR VPWR sky130_fd_sc_hd__fill_2
XFILLER_0_23_31 VPWR VGND VPWR VGND sky130_ef_sc_hd__decap_12
XANTENNA__4666__RESET_B tree_instances\[0\].u_tree.rst_n VGND VGND VPWR VPWR sky130_fd_sc_hd__diode_2
XFILLER_0_7_449 VPWR VGND VPWR VGND sky130_ef_sc_hd__decap_12
XFILLER_0_7_416 VGND VGND VPWR VPWR sky130_fd_sc_hd__fill_2
XFILLER_0_23_86 VPWR VGND VPWR VGND sky130_ef_sc_hd__decap_12
XFILLER_0_28_566 VGND VGND VPWR VPWR sky130_fd_sc_hd__decap_8
X_4771_ clknet_leaf_49_clk _0014_ net10 VGND VGND VPWR VPWR tree_instances\[15\].u_tree.tree_state\[2\]
+ sky130_fd_sc_hd__dfrtp_1
XFILLER_0_55_330 VGND VGND VPWR VPWR sky130_fd_sc_hd__fill_2
XFILLER_0_55_341 VGND VGND VPWR VPWR sky130_fd_sc_hd__fill_1
X_3722_ _1198_ VGND VGND VPWR VPWR _0311_ sky130_fd_sc_hd__clkbuf_1
XFILLER_0_15_205 VGND VGND VPWR VPWR sky130_fd_sc_hd__fill_1
XFILLER_0_70_322 VPWR VGND VPWR VGND sky130_ef_sc_hd__decap_12
X_3653_ tree_instances\[7\].u_tree.pipeline_current_node\[0\]\[7\] _1138_ VGND VGND
+ VPWR VPWR _1160_ sky130_fd_sc_hd__and2_1
X_2604_ _1932_ _1934_ VGND VGND VPWR VPWR _0063_ sky130_fd_sc_hd__nand2_1
XFILLER_0_2_121 VGND VGND VPWR VPWR sky130_fd_sc_hd__decap_4
X_3584_ tree_instances\[6\].u_tree.pipeline_current_node\[0\]\[5\] VGND VGND VPWR
+ VPWR _1114_ sky130_fd_sc_hd__clkbuf_1
XTAP_TAPCELL_ROW_93_1143 VGND VPWR sky130_fd_sc_hd__tapvpwrvgnd_1
X_2535_ _1875_ VGND VGND VPWR VPWR _1876_ sky130_fd_sc_hd__clkbuf_1
X_2466_ tree_instances\[4\].u_tree.pipeline_current_node\[0\]\[5\] _1816_ VGND VGND
+ VPWR VPWR _1817_ sky130_fd_sc_hd__or2_1
X_4205_ _1432_ _1478_ VGND VGND VPWR VPWR _1484_ sky130_fd_sc_hd__and2_1
X_2397_ tree_instances\[12\].u_tree.pipeline_current_node\[0\]\[2\] VGND VGND VPWR
+ VPWR _1755_ sky130_fd_sc_hd__clkbuf_1
X_4136_ _1438_ VGND VGND VPWR VPWR _1441_ sky130_fd_sc_hd__clkbuf_1
XFILLER_0_64_71 VGND VGND VPWR VPWR sky130_fd_sc_hd__fill_2
X_4067_ _1395_ VGND VGND VPWR VPWR _0459_ sky130_fd_sc_hd__clkbuf_1
X_3018_ _0689_ VGND VGND VPWR VPWR _0690_ sky130_fd_sc_hd__buf_2
XTAP_TAPCELL_ROW_54_748 VGND VPWR sky130_fd_sc_hd__tapvpwrvgnd_1
XFILLER_0_65_116 VGND VGND VPWR VPWR sky130_fd_sc_hd__decap_3
XFILLER_0_19_533 VGND VGND VPWR VPWR sky130_fd_sc_hd__decap_3
XANTENNA__4336__RESET_B net11 VGND VGND VPWR VPWR sky130_fd_sc_hd__diode_2
XFILLER_0_46_352 VGND VGND VPWR VPWR sky130_fd_sc_hd__decap_6
XFILLER_0_80_119 VGND VGND VPWR VPWR sky130_fd_sc_hd__fill_1
XFILLER_0_61_355 VGND VGND VPWR VPWR sky130_fd_sc_hd__decap_4
XFILLER_0_69_433 VPWR VGND VPWR VGND sky130_ef_sc_hd__decap_12
XANTENNA_clkbuf_leaf_70_clk_A clknet_3_0__leaf_clk VGND VGND VPWR VPWR sky130_fd_sc_hd__diode_2
XFILLER_0_84_458 VGND VGND VPWR VPWR sky130_fd_sc_hd__decap_4
XPHY_EDGE_ROW_7_Left_104 VGND VGND VPWR VPWR sky130_fd_sc_hd__decap_3
XTAP_TAPCELL_ROW_25_461 VGND VPWR sky130_fd_sc_hd__tapvpwrvgnd_1
XFILLER_0_37_330 VGND VGND VPWR VPWR sky130_fd_sc_hd__fill_1
XFILLER_0_71_108 VGND VGND VPWR VPWR sky130_fd_sc_hd__fill_1
XFILLER_0_25_503 VGND VGND VPWR VPWR sky130_fd_sc_hd__fill_1
XFILLER_0_64_182 VGND VGND VPWR VPWR sky130_fd_sc_hd__fill_2
X_2320_ tree_instances\[7\].u_tree.tree_state\[0\] _1686_ VGND VGND VPWR VPWR _1687_
+ sky130_fd_sc_hd__nand2_1
XANTENNA__3147__A1_N _0648_ VGND VGND VPWR VPWR sky130_fd_sc_hd__diode_2
X_2251_ _1615_ _1620_ _1623_ _1626_ VGND VGND VPWR VPWR _1627_ sky130_fd_sc_hd__and4_1
XANTENNA_clkbuf_leaf_23_clk_A clknet_3_3__leaf_clk VGND VGND VPWR VPWR sky130_fd_sc_hd__diode_2
X_2182_ _1560_ _1564_ VGND VGND VPWR VPWR _1565_ sky130_fd_sc_hd__or2_1
XFILLER_0_18_64 VGND VGND VPWR VPWR sky130_fd_sc_hd__fill_2
XANTENNA__4847__RESET_B net10 VGND VGND VPWR VPWR sky130_fd_sc_hd__diode_2
XANTENNA_clkbuf_leaf_38_clk_A clknet_3_7__leaf_clk VGND VGND VPWR VPWR sky130_fd_sc_hd__diode_2
XFILLER_0_87_252 VGND VGND VPWR VPWR sky130_fd_sc_hd__fill_2
XFILLER_0_87_241 VGND VGND VPWR VPWR sky130_fd_sc_hd__fill_2
XFILLER_0_34_41 VGND VGND VPWR VPWR sky130_fd_sc_hd__decap_3
XANTENNA__3804__A1 _1192_ VGND VGND VPWR VPWR sky130_fd_sc_hd__diode_2
XFILLER_0_75_447 VGND VGND VPWR VPWR sky130_fd_sc_hd__fill_1
XFILLER_0_34_85 VGND VGND VPWR VPWR sky130_fd_sc_hd__fill_2
XFILLER_0_34_96 VPWR VGND VPWR VGND sky130_ef_sc_hd__decap_12
XANTENNA__3201__A _0653_ VGND VGND VPWR VPWR sky130_fd_sc_hd__diode_2
XTAP_TAPCELL_ROW_51_718 VGND VPWR sky130_fd_sc_hd__tapvpwrvgnd_1
X_4823_ clknet_leaf_50_clk _0505_ net10 VGND VGND VPWR VPWR tree_instances\[18\].u_tree.pipeline_current_node\[0\]\[1\]
+ sky130_fd_sc_hd__dfrtp_1
XFILLER_0_28_363 VGND VGND VPWR VPWR sky130_fd_sc_hd__fill_1
XFILLER_0_43_311 VGND VGND VPWR VPWR sky130_fd_sc_hd__fill_2
X_4754_ clknet_leaf_44_clk _0451_ net13 VGND VGND VPWR VPWR tree_instances\[15\].u_tree.pipeline_frame_id\[0\]\[1\]
+ sky130_fd_sc_hd__dfrtp_1
X_3705_ _1189_ VGND VGND VPWR VPWR _0303_ sky130_fd_sc_hd__clkbuf_1
XFILLER_0_7_279 VGND VGND VPWR VPWR sky130_fd_sc_hd__fill_1
XFILLER_0_43_322 VGND VGND VPWR VPWR sky130_fd_sc_hd__fill_1
XFILLER_0_70_141 VGND VGND VPWR VPWR sky130_fd_sc_hd__fill_1
X_4685_ clknet_leaf_14_clk _0389_ net12 VGND VGND VPWR VPWR tree_instances\[12\].u_tree.pipeline_frame_id\[0\]\[2\]
+ sky130_fd_sc_hd__dfrtp_1
XFILLER_0_16_569 VGND VGND VPWR VPWR sky130_fd_sc_hd__decap_4
X_3636_ _1147_ VGND VGND VPWR VPWR _0276_ sky130_fd_sc_hd__clkbuf_1
XFILLER_0_3_441 VGND VGND VPWR VPWR sky130_fd_sc_hd__decap_6
X_3567_ _1100_ _1096_ VGND VGND VPWR VPWR _1101_ sky130_fd_sc_hd__and2_1
XFILLER_0_3_485 VPWR VGND VPWR VGND sky130_ef_sc_hd__decap_12
X_2518_ _1862_ _1718_ VGND VGND VPWR VPWR _1863_ sky130_fd_sc_hd__nor2_1
X_3498_ _1052_ _1054_ VGND VGND VPWR VPWR _1055_ sky130_fd_sc_hd__and2_1
XANTENNA__4178__S _0018_ VGND VGND VPWR VPWR sky130_fd_sc_hd__diode_2
X_2449_ _1800_ _1801_ VGND VGND VPWR VPWR _1802_ sky130_fd_sc_hd__or2_1
X_4119_ _1424_ VGND VGND VPWR VPWR _1425_ sky130_fd_sc_hd__clkbuf_1
XANTENNA__4048__A1 _0664_ VGND VGND VPWR VPWR sky130_fd_sc_hd__diode_2
XANTENNA__4588__RESET_B net11 VGND VGND VPWR VPWR sky130_fd_sc_hd__diode_2
XANTENNA__4517__RESET_B tree_instances\[0\].u_tree.rst_n VGND VGND VPWR VPWR sky130_fd_sc_hd__diode_2
XTAP_TAPCELL_ROW_39_597 VGND VPWR sky130_fd_sc_hd__tapvpwrvgnd_1
XFILLER_0_93_222 VGND VGND VPWR VPWR sky130_fd_sc_hd__fill_2
XFILLER_0_38_105 VGND VGND VPWR VPWR sky130_fd_sc_hd__fill_2
XFILLER_0_38_138 VGND VGND VPWR VPWR sky130_fd_sc_hd__fill_2
XTAP_TAPCELL_ROW_22_431 VGND VPWR sky130_fd_sc_hd__tapvpwrvgnd_1
XFILLER_0_53_119 VGND VGND VPWR VPWR sky130_fd_sc_hd__fill_1
XFILLER_0_34_333 VPWR VGND VPWR VGND sky130_ef_sc_hd__decap_12
XFILLER_0_46_193 VGND VGND VPWR VPWR sky130_fd_sc_hd__decap_3
XFILLER_0_61_163 VGND VGND VPWR VPWR sky130_fd_sc_hd__decap_3
XFILLER_0_22_506 VGND VGND VPWR VPWR sky130_fd_sc_hd__fill_1
XFILLER_0_34_355 VGND VGND VPWR VPWR sky130_fd_sc_hd__decap_6
XFILLER_0_34_388 VGND VGND VPWR VPWR sky130_fd_sc_hd__fill_2
XPHY_EDGE_ROW_89_Left_186 VGND VGND VPWR VPWR sky130_fd_sc_hd__decap_3
XFILLER_0_30_572 VGND VGND VPWR VPWR sky130_fd_sc_hd__fill_2
XFILLER_0_71_39 VPWR VGND VPWR VGND sky130_ef_sc_hd__decap_12
XFILLER_0_69_285 VPWR VGND VPWR VGND sky130_ef_sc_hd__decap_12
XFILLER_0_57_469 VGND VGND VPWR VPWR sky130_fd_sc_hd__fill_2
XFILLER_0_25_322 VGND VGND VPWR VPWR sky130_fd_sc_hd__fill_1
XFILLER_0_13_517 VPWR VGND VPWR VGND sky130_ef_sc_hd__decap_12
XFILLER_0_52_141 VGND VGND VPWR VPWR sky130_fd_sc_hd__fill_1
XANTENNA__3071__A1_N _0695_ VGND VGND VPWR VPWR sky130_fd_sc_hd__diode_2
X_4470_ clknet_leaf_56_clk _0210_ net9 VGND VGND VPWR VPWR tree_instances\[4\].u_tree.pipeline_current_node\[0\]\[0\]
+ sky130_fd_sc_hd__dfrtp_1
X_3421_ _1008_ VGND VGND VPWR VPWR _0200_ sky130_fd_sc_hd__clkbuf_1
XFILLER_0_96_69 VPWR VGND VPWR VGND sky130_ef_sc_hd__decap_12
XTAP_TAPCELL_ROW_90_1113 VGND VPWR sky130_fd_sc_hd__tapvpwrvgnd_1
X_3352_ _0968_ VGND VGND VPWR VPWR _0969_ sky130_fd_sc_hd__clkbuf_1
XFILLER_0_0_433 VGND VGND VPWR VPWR sky130_fd_sc_hd__decap_4
XFILLER_0_21_561 VPWR VGND VPWR VGND sky130_ef_sc_hd__decap_12
XFILLER_0_0_477 VPWR VGND VPWR VGND sky130_ef_sc_hd__decap_12
X_2303_ tree_instances\[7\].u_tree.pipeline_current_node\[0\]\[0\] VGND VGND VPWR
+ VPWR _1671_ sky130_fd_sc_hd__clkbuf_1
X_3283_ _0929_ VGND VGND VPWR VPWR _0141_ sky130_fd_sc_hd__clkbuf_1
X_2234_ _1607_ _1610_ VGND VGND VPWR VPWR _1611_ sky130_fd_sc_hd__nor2_1
X_2165_ tree_instances\[1\].u_tree.ready_for_next tree_instances\[0\].u_tree.ready_for_next
+ _1548_ VGND VGND VPWR VPWR _1549_ sky130_fd_sc_hd__and3_1
XANTENNA__4681__RESET_B net11 VGND VGND VPWR VPWR sky130_fd_sc_hd__diode_2
XFILLER_0_45_51 VGND VGND VPWR VPWR sky130_fd_sc_hd__decap_4
XTAP_TAPCELL_ROW_88_1086 VGND VPWR sky130_fd_sc_hd__tapvpwrvgnd_1
XANTENNA__4610__RESET_B tree_instances\[0\].u_tree.rst_n VGND VGND VPWR VPWR sky130_fd_sc_hd__diode_2
XFILLER_0_48_403 VGND VGND VPWR VPWR sky130_fd_sc_hd__decap_8
XTAP_TAPCELL_ROW_36_567 VGND VPWR sky130_fd_sc_hd__tapvpwrvgnd_1
XFILLER_0_0_53 VGND VGND VPWR VPWR sky130_fd_sc_hd__decap_3
XFILLER_0_75_277 VGND VGND VPWR VPWR sky130_fd_sc_hd__decap_3
XFILLER_0_8_533 VPWR VGND VPWR VGND sky130_ef_sc_hd__decap_12
XFILLER_0_0_97 VPWR VGND VPWR VGND sky130_ef_sc_hd__decap_12
X_4806_ clknet_leaf_46_clk _0493_ net13 VGND VGND VPWR VPWR tree_instances\[17\].u_tree.pipeline_frame_id\[0\]\[1\]
+ sky130_fd_sc_hd__dfrtp_1
XFILLER_0_35_108 VGND VGND VPWR VPWR sky130_fd_sc_hd__decap_4
XFILLER_0_90_225 VPWR VGND VPWR VGND sky130_ef_sc_hd__decap_12
X_2998_ _0673_ _0671_ VGND VGND VPWR VPWR _0112_ sky130_fd_sc_hd__xor2_1
XFILLER_0_28_193 VGND VGND VPWR VPWR sky130_fd_sc_hd__decap_3
X_4737_ clknet_leaf_25_clk _0435_ net11 VGND VGND VPWR VPWR tree_instances\[14\].u_tree.frame_id_out\[1\]
+ sky130_fd_sc_hd__dfrtp_1
XFILLER_0_9_51 VGND VGND VPWR VPWR sky130_fd_sc_hd__decap_4
XFILLER_0_16_344 VPWR VGND VPWR VGND sky130_ef_sc_hd__decap_12
X_4668_ clknet_leaf_9_clk _0373_ net12 VGND VGND VPWR VPWR tree_instances\[11\].u_tree.frame_id_out\[2\]
+ sky130_fd_sc_hd__dfrtp_1
XFILLER_0_16_377 VGND VGND VPWR VPWR sky130_fd_sc_hd__decap_8
XFILLER_0_16_388 VGND VGND VPWR VPWR sky130_fd_sc_hd__decap_6
X_3619_ _1750_ _1134_ _0620_ tree_instances\[6\].u_tree.ready_for_next VGND VGND VPWR
+ VPWR _0272_ sky130_fd_sc_hd__a22o_1
XFILLER_0_3_271 VGND VGND VPWR VPWR sky130_fd_sc_hd__fill_1
X_4599_ clknet_leaf_0_clk _0314_ net9 VGND VGND VPWR VPWR tree_instances\[9\].u_tree.pipeline_current_node\[0\]\[0\]
+ sky130_fd_sc_hd__dfrtp_1
XFILLER_0_86_80 VGND VGND VPWR VPWR sky130_fd_sc_hd__decap_4
XANTENNA__3106__A _0657_ VGND VGND VPWR VPWR sky130_fd_sc_hd__diode_2
XFILLER_0_79_572 VGND VGND VPWR VPWR sky130_fd_sc_hd__fill_2
XANTENNA__4351__RESET_B net11 VGND VGND VPWR VPWR sky130_fd_sc_hd__diode_2
XFILLER_0_39_425 VGND VGND VPWR VPWR sky130_fd_sc_hd__fill_1
XFILLER_0_94_531 VGND VGND VPWR VPWR sky130_fd_sc_hd__fill_1
XFILLER_0_39_447 VGND VGND VPWR VPWR sky130_fd_sc_hd__fill_1
XFILLER_0_66_288 VGND VGND VPWR VPWR sky130_fd_sc_hd__decap_4
XFILLER_0_81_225 VGND VGND VPWR VPWR sky130_fd_sc_hd__fill_2
XFILLER_0_34_141 VGND VGND VPWR VPWR sky130_fd_sc_hd__decap_3
XFILLER_0_62_472 VGND VGND VPWR VPWR sky130_fd_sc_hd__decap_4
XFILLER_0_1_208 VGND VGND VPWR VPWR sky130_fd_sc_hd__fill_2
XTAP_TAPCELL_ROW_7_281 VGND VPWR sky130_fd_sc_hd__tapvpwrvgnd_1
XPHY_EDGE_ROW_13_Right_13 VGND VGND VPWR VPWR sky130_fd_sc_hd__decap_3
XANTENNA__4439__RESET_B net13 VGND VGND VPWR VPWR sky130_fd_sc_hd__diode_2
XFILLER_0_15_43 VPWR VGND VPWR VGND sky130_ef_sc_hd__decap_12
X_3970_ tree_instances\[13\].u_tree.pipeline_frame_id\[0\]\[4\] _1168_ _0010_ VGND
+ VGND VPWR VPWR _1346_ sky130_fd_sc_hd__mux2_1
XFILLER_0_85_542 VPWR VGND VPWR VGND sky130_ef_sc_hd__decap_12
XFILLER_0_15_98 VPWR VGND VPWR VGND sky130_ef_sc_hd__decap_12
X_2921_ _0618_ VGND VGND VPWR VPWR _0004_ sky130_fd_sc_hd__inv_2
XTAP_TAPCELL_ROW_33_537 VGND VPWR sky130_fd_sc_hd__tapvpwrvgnd_1
X_2852_ tree_instances\[1\].u_tree.pipeline_current_node\[0\]\[6\] VGND VGND VPWR
+ VPWR _2154_ sky130_fd_sc_hd__clkbuf_1
XFILLER_0_72_214 VGND VGND VPWR VPWR sky130_fd_sc_hd__fill_2
XFILLER_0_5_503 VGND VGND VPWR VPWR sky130_fd_sc_hd__fill_1
XPHY_EDGE_ROW_22_Right_22 VGND VGND VPWR VPWR sky130_fd_sc_hd__decap_3
XFILLER_0_31_75 VPWR VGND VPWR VGND sky130_ef_sc_hd__decap_12
X_2783_ _2089_ VGND VGND VPWR VPWR _0091_ sky130_fd_sc_hd__clkbuf_1
XFILLER_0_80_280 VPWR VGND VPWR VGND sky130_ef_sc_hd__decap_12
X_4522_ clknet_leaf_9_clk _0252_ net12 VGND VGND VPWR VPWR tree_instances\[11\].u_tree.pipeline_valid\[0\]
+ sky130_fd_sc_hd__dfrtp_1
XFILLER_0_25_163 VGND VGND VPWR VPWR sky130_fd_sc_hd__fill_1
X_4453_ clknet_leaf_69_clk _0194_ tree_instances\[0\].u_tree.rst_n VGND VGND VPWR
+ VPWR tree_instances\[3\].u_tree.pipeline_current_node\[0\]\[5\] sky130_fd_sc_hd__dfrtp_1
XFILLER_0_40_133 VGND VGND VPWR VPWR sky130_fd_sc_hd__decap_6
X_3404_ _2112_ _0996_ VGND VGND VPWR VPWR _1000_ sky130_fd_sc_hd__and2_1
XFILLER_0_40_155 VGND VGND VPWR VPWR sky130_fd_sc_hd__fill_2
X_4384_ clknet_leaf_36_clk _0132_ net10 VGND VGND VPWR VPWR tree_instances\[0\].u_tree.pipeline_current_node\[0\]\[6\]
+ sky130_fd_sc_hd__dfrtp_1
XTAP_TAPCELL_ROW_69_902 VGND VPWR sky130_fd_sc_hd__tapvpwrvgnd_1
X_3335_ tree_instances\[15\].u_tree.tree_state\[0\] _1935_ VGND VGND VPWR VPWR _0956_
+ sky130_fd_sc_hd__nand2_1
X_3266_ _0920_ VGND VGND VPWR VPWR _0133_ sky130_fd_sc_hd__clkbuf_1
XANTENNA__4862__RESET_B net13 VGND VGND VPWR VPWR sky130_fd_sc_hd__diode_2
XPHY_EDGE_ROW_31_Right_31 VGND VGND VPWR VPWR sky130_fd_sc_hd__decap_3
X_2217_ tree_instances\[11\].u_tree.tree_state\[0\] _1594_ _1595_ VGND VGND VPWR VPWR
+ _0046_ sky130_fd_sc_hd__a21o_1
XFILLER_0_56_83 VGND VGND VPWR VPWR sky130_fd_sc_hd__fill_1
XFILLER_0_22_3 VGND VGND VPWR VPWR sky130_fd_sc_hd__decap_4
X_3197_ current_voting_frame\[3\] tree_instances\[13\].u_tree.frame_id_out\[3\] VGND
+ VGND VPWR VPWR _0869_ sky130_fd_sc_hd__nor2_1
XFILLER_0_76_520 VPWR VGND VPWR VGND sky130_ef_sc_hd__decap_12
XFILLER_0_88_391 VGND VGND VPWR VPWR sky130_fd_sc_hd__fill_2
XFILLER_0_48_222 VGND VGND VPWR VPWR sky130_fd_sc_hd__fill_2
XANTENNA__2985__A1 net6 VGND VGND VPWR VPWR sky130_fd_sc_hd__diode_2
XFILLER_0_91_556 VGND VGND VPWR VPWR sky130_fd_sc_hd__decap_4
XFILLER_0_63_225 VPWR VGND VPWR VGND sky130_ef_sc_hd__decap_12
XPHY_EDGE_ROW_40_Right_40 VGND VGND VPWR VPWR sky130_fd_sc_hd__decap_3
XFILLER_0_16_141 VGND VGND VPWR VPWR sky130_fd_sc_hd__fill_2
XFILLER_0_71_291 VGND VGND VPWR VPWR sky130_fd_sc_hd__fill_2
XFILLER_0_31_133 VGND VGND VPWR VPWR sky130_fd_sc_hd__fill_2
XANTENNA__4532__RESET_B net11 VGND VGND VPWR VPWR sky130_fd_sc_hd__diode_2
XTAP_TAPCELL_ROW_4_251 VGND VPWR sky130_fd_sc_hd__tapvpwrvgnd_1
XFILLER_0_59_509 VGND VGND VPWR VPWR sky130_fd_sc_hd__fill_1
XFILLER_0_86_317 VGND VGND VPWR VPWR sky130_fd_sc_hd__fill_1
XFILLER_0_67_520 VGND VGND VPWR VPWR sky130_fd_sc_hd__decap_3
XFILLER_0_67_542 VGND VGND VPWR VPWR sky130_fd_sc_hd__fill_1
XFILLER_0_82_501 VGND VGND VPWR VPWR sky130_fd_sc_hd__decap_6
XFILLER_0_27_406 VPWR VGND VPWR VGND sky130_ef_sc_hd__decap_12
XFILLER_0_82_545 VGND VGND VPWR VPWR sky130_fd_sc_hd__fill_2
XTAP_TAPCELL_ROW_30_507 VGND VPWR sky130_fd_sc_hd__tapvpwrvgnd_1
XFILLER_0_22_133 VGND VGND VPWR VPWR sky130_fd_sc_hd__fill_1
XFILLER_0_50_442 VPWR VGND VPWR VGND sky130_ef_sc_hd__decap_12
XANTENNA__3153__A1 _0655_ VGND VGND VPWR VPWR sky130_fd_sc_hd__diode_2
X_3120_ _0694_ tree_instances\[2\].u_tree.frame_id_out\[0\] tree_instances\[2\].u_tree.frame_id_out\[2\]
+ _0714_ VGND VGND VPWR VPWR _0792_ sky130_fd_sc_hd__a22oi_1
XFILLER_0_93_15 VPWR VGND VPWR VGND sky130_ef_sc_hd__decap_12
XFILLER_0_89_100 VGND VGND VPWR VPWR sky130_fd_sc_hd__fill_2
X_3051_ tree_instances\[15\].u_tree.frame_id_out\[3\] VGND VGND VPWR VPWR _0723_ sky130_fd_sc_hd__inv_2
XFILLER_0_89_144 VPWR VGND VPWR VGND sky130_ef_sc_hd__decap_12
XFILLER_0_26_53 VPWR VGND VPWR VGND sky130_ef_sc_hd__decap_12
XFILLER_0_89_188 VGND VGND VPWR VPWR sky130_fd_sc_hd__fill_2
XTAP_TAPCELL_ROW_85_1056 VGND VPWR sky130_fd_sc_hd__tapvpwrvgnd_1
XTAP_TAPCELL_ROW_46_673 VGND VPWR sky130_fd_sc_hd__tapvpwrvgnd_1
XFILLER_0_92_309 VGND VGND VPWR VPWR sky130_fd_sc_hd__fill_1
X_3953_ _1337_ VGND VGND VPWR VPWR _0403_ sky130_fd_sc_hd__clkbuf_1
XTAP_TAPCELL_ROW_18_386 VGND VPWR sky130_fd_sc_hd__tapvpwrvgnd_1
X_3884_ _1293_ VGND VGND VPWR VPWR _1294_ sky130_fd_sc_hd__dlymetal6s2s_1
X_2904_ tree_instances\[11\].u_tree.tree_state\[0\] VGND VGND VPWR VPWR _0607_ sky130_fd_sc_hd__inv_2
XFILLER_0_42_74 VGND VGND VPWR VPWR sky130_fd_sc_hd__fill_2
XFILLER_0_42_85 VGND VGND VPWR VPWR sky130_fd_sc_hd__decap_4
X_2835_ _2137_ VGND VGND VPWR VPWR _2138_ sky130_fd_sc_hd__clkbuf_1
XFILLER_0_73_556 VGND VGND VPWR VPWR sky130_fd_sc_hd__decap_4
X_2766_ _1653_ VGND VGND VPWR VPWR _2074_ sky130_fd_sc_hd__clkbuf_1
XFILLER_0_5_377 VGND VGND VPWR VPWR sky130_fd_sc_hd__decap_4
XFILLER_0_53_291 VGND VGND VPWR VPWR sky130_fd_sc_hd__fill_2
XTAP_TAPCELL_ROW_96_1174 VGND VPWR sky130_fd_sc_hd__tapvpwrvgnd_1
X_2697_ tree_instances\[12\].u_tree.pipeline_current_node\[0\]\[8\] VGND VGND VPWR
+ VPWR _2016_ sky130_fd_sc_hd__clkbuf_1
X_4505_ clknet_leaf_51_clk _0236_ net13 VGND VGND VPWR VPWR tree_instances\[5\].u_tree.pipeline_current_node\[0\]\[5\]
+ sky130_fd_sc_hd__dfrtp_1
XFILLER_0_6_41 VPWR VGND VPWR VGND sky130_ef_sc_hd__decap_12
XFILLER_0_1_561 VPWR VGND VPWR VGND sky130_ef_sc_hd__decap_12
X_4436_ clknet_leaf_58_clk _0182_ net13 VGND VGND VPWR VPWR tree_instances\[2\].u_tree.frame_id_out\[0\]
+ sky130_fd_sc_hd__dfrtp_1
X_4367_ clknet_leaf_0_clk _0041_ net9 VGND VGND VPWR VPWR tree_instances\[9\].u_tree.tree_state\[1\]
+ sky130_fd_sc_hd__dfrtp_1
XANTENNA__3144__A1 _0691_ VGND VGND VPWR VPWR sky130_fd_sc_hd__diode_2
X_3318_ tree_instances\[1\].u_tree.pipeline_frame_id\[0\]\[2\] _0675_ _0024_ VGND
+ VGND VPWR VPWR _0948_ sky130_fd_sc_hd__mux2_1
XFILLER_0_6_85 VGND VGND VPWR VPWR sky130_fd_sc_hd__decap_8
X_4298_ tree_instances\[20\].u_tree.pipeline_current_node\[0\]\[7\] _1523_ VGND VGND
+ VPWR VPWR _1532_ sky130_fd_sc_hd__and2_1
X_3249_ tree_instances\[0\].u_tree.tree_state\[2\] tree_instances\[0\].u_tree.tree_state\[1\]
+ _0614_ VGND VGND VPWR VPWR _0911_ sky130_fd_sc_hd__or3_1
XANTENNA__4186__S _1827_ VGND VGND VPWR VPWR sky130_fd_sc_hd__diode_2
XTAP_TAPCELL_ROW_1_221 VGND VPWR sky130_fd_sc_hd__tapvpwrvgnd_1
XFILLER_0_95_169 VGND VGND VPWR VPWR sky130_fd_sc_hd__fill_2
XFILLER_0_64_523 VGND VGND VPWR VPWR sky130_fd_sc_hd__fill_2
XFILLER_0_91_353 VPWR VGND VPWR VGND sky130_ef_sc_hd__decap_12
XFILLER_0_17_461 VGND VGND VPWR VPWR sky130_fd_sc_hd__fill_2
XANTENNA__4784__RESET_B net10 VGND VGND VPWR VPWR sky130_fd_sc_hd__diode_2
XANTENNA__4713__RESET_B net9 VGND VGND VPWR VPWR sky130_fd_sc_hd__diode_2
XFILLER_0_86_114 VPWR VGND VPWR VGND sky130_ef_sc_hd__decap_12
XFILLER_0_74_309 VGND VGND VPWR VPWR sky130_fd_sc_hd__decap_8
XFILLER_0_67_350 VGND VGND VPWR VPWR sky130_fd_sc_hd__decap_8
XTAP_TAPCELL_ROW_43_643 VGND VPWR sky130_fd_sc_hd__tapvpwrvgnd_1
XFILLER_0_55_501 VGND VGND VPWR VPWR sky130_fd_sc_hd__decap_3
XTAP_TAPCELL_ROW_15_356 VGND VPWR sky130_fd_sc_hd__tapvpwrvgnd_1
XFILLER_0_12_33 VGND VGND VPWR VPWR sky130_fd_sc_hd__fill_2
X_2620_ tree_instances\[19\].u_tree.pipeline_current_node\[0\]\[6\] VGND VGND VPWR
+ VPWR _1948_ sky130_fd_sc_hd__inv_2
XFILLER_0_70_537 VGND VGND VPWR VPWR sky130_fd_sc_hd__fill_1
XFILLER_0_12_55 VGND VGND VPWR VPWR sky130_fd_sc_hd__decap_6
XFILLER_0_88_15 VGND VGND VPWR VPWR sky130_fd_sc_hd__decap_4
X_2551_ _1666_ tree_instances\[2\].u_tree.pipeline_valid\[0\] VGND VGND VPWR VPWR
+ _1890_ sky130_fd_sc_hd__or2_1
XANTENNA__3374__A1 _0673_ VGND VGND VPWR VPWR sky130_fd_sc_hd__diode_2
XFILLER_0_23_453 VGND VGND VPWR VPWR sky130_fd_sc_hd__decap_4
XFILLER_0_10_103 VPWR VGND VPWR VGND sky130_ef_sc_hd__decap_12
X_2482_ _1830_ VGND VGND VPWR VPWR _0058_ sky130_fd_sc_hd__clkbuf_1
XANTENNA__4454__RESET_B net9 VGND VGND VPWR VPWR sky130_fd_sc_hd__diode_2
X_4221_ tree_instances\[18\].u_tree.pipeline_frame_id\[0\]\[4\] tree_instances\[0\].u_tree.frame_id_in\[4\]
+ _0020_ VGND VGND VPWR VPWR _1492_ sky130_fd_sc_hd__mux2_1
X_4152_ _1453_ VGND VGND VPWR VPWR _0486_ sky130_fd_sc_hd__clkbuf_1
X_3103_ _0733_ tree_instances\[0\].u_tree.frame_id_out\[1\] VGND VGND VPWR VPWR _0775_
+ sky130_fd_sc_hd__xor2_1
X_4083_ _1404_ VGND VGND VPWR VPWR _0466_ sky130_fd_sc_hd__clkbuf_1
XFILLER_0_37_63 VPWR VGND VPWR VGND sky130_ef_sc_hd__decap_12
X_3034_ _0702_ tree_instances\[7\].u_tree.frame_id_out\[3\] tree_instances\[7\].u_tree.frame_id_out\[4\]
+ _0697_ _0705_ VGND VGND VPWR VPWR _0706_ sky130_fd_sc_hd__a221o_1
XFILLER_0_77_103 VGND VGND VPWR VPWR sky130_fd_sc_hd__fill_2
XFILLER_0_77_169 VGND VGND VPWR VPWR sky130_fd_sc_hd__fill_2
XFILLER_0_53_95 VGND VGND VPWR VPWR sky130_fd_sc_hd__fill_2
XFILLER_0_92_139 VGND VGND VPWR VPWR sky130_fd_sc_hd__fill_1
XFILLER_0_92_128 VGND VGND VPWR VPWR sky130_fd_sc_hd__decap_4
X_3936_ _1325_ VGND VGND VPWR VPWR _1326_ sky130_fd_sc_hd__clkbuf_1
XFILLER_0_73_342 VGND VGND VPWR VPWR sky130_fd_sc_hd__fill_2
XFILLER_0_73_331 VGND VGND VPWR VPWR sky130_fd_sc_hd__decap_4
XFILLER_0_18_269 VPWR VGND VPWR VGND sky130_ef_sc_hd__decap_12
XFILLER_0_46_545 VPWR VGND VPWR VGND sky130_ef_sc_hd__decap_12
X_3867_ _1732_ VGND VGND VPWR VPWR _1277_ sky130_fd_sc_hd__clkbuf_1
XFILLER_0_33_217 VGND VGND VPWR VPWR sky130_fd_sc_hd__fill_2
X_2818_ _2114_ VGND VGND VPWR VPWR _2122_ sky130_fd_sc_hd__clkbuf_1
X_3798_ tree_instances\[10\].u_tree.pipeline_frame_id\[0\]\[0\] _1162_ _0004_ VGND
+ VGND VPWR VPWR _1242_ sky130_fd_sc_hd__mux2_1
XFILLER_0_14_475 VGND VGND VPWR VPWR sky130_fd_sc_hd__fill_1
XFILLER_0_14_464 VGND VGND VPWR VPWR sky130_fd_sc_hd__fill_2
X_2749_ _2059_ VGND VGND VPWR VPWR _2060_ sky130_fd_sc_hd__clkbuf_1
XFILLER_0_41_250 VGND VGND VPWR VPWR sky130_fd_sc_hd__decap_6
XANTENNA_load_slew9_A tree_instances\[0\].u_tree.rst_n VGND VGND VPWR VPWR sky130_fd_sc_hd__diode_2
XPHY_EDGE_ROW_52_Left_149 VGND VGND VPWR VPWR sky130_fd_sc_hd__decap_3
XANTENNA__3117__A1 _0662_ VGND VGND VPWR VPWR sky130_fd_sc_hd__diode_2
X_4419_ clknet_leaf_31_clk _0166_ net11 VGND VGND VPWR VPWR tree_instances\[1\].u_tree.ready_for_next
+ sky130_fd_sc_hd__dfstp_1
XTAP_TAPCELL_ROW_57_779 VGND VPWR sky130_fd_sc_hd__tapvpwrvgnd_1
XFILLER_0_96_445 VGND VGND VPWR VPWR sky130_fd_sc_hd__decap_3
XPHY_EDGE_ROW_61_Left_158 VGND VGND VPWR VPWR sky130_fd_sc_hd__decap_3
XFILLER_0_96_489 VPWR VGND VPWR VGND sky130_ef_sc_hd__decap_12
XTAP_TAPCELL_ROW_12_326 VGND VPWR sky130_fd_sc_hd__tapvpwrvgnd_1
XFILLER_0_37_567 VGND VGND VPWR VPWR sky130_fd_sc_hd__decap_6
XTAP_TAPCELL_ROW_40_613 VGND VPWR sky130_fd_sc_hd__tapvpwrvgnd_1
XFILLER_0_52_526 VGND VGND VPWR VPWR sky130_fd_sc_hd__decap_6
XPHY_EDGE_ROW_70_Left_167 VGND VGND VPWR VPWR sky130_fd_sc_hd__decap_3
XFILLER_0_58_29 VGND VGND VPWR VPWR sky130_fd_sc_hd__decap_8
XANTENNA__3024__A _0695_ VGND VGND VPWR VPWR sky130_fd_sc_hd__diode_2
XFILLER_0_90_27 VGND VGND VPWR VPWR sky130_fd_sc_hd__fill_1
XTAP_TAPCELL_ROW_82_1026 VGND VPWR sky130_fd_sc_hd__tapvpwrvgnd_1
XTAP_TAPCELL_ROW_28_492 VGND VPWR sky130_fd_sc_hd__tapvpwrvgnd_1
XFILLER_0_23_43 VGND VGND VPWR VPWR sky130_fd_sc_hd__fill_1
XFILLER_0_23_54 VGND VGND VPWR VPWR sky130_fd_sc_hd__fill_2
X_4770_ clknet_leaf_49_clk _0013_ net10 VGND VGND VPWR VPWR tree_instances\[15\].u_tree.tree_state\[1\]
+ sky130_fd_sc_hd__dfrtp_1
X_3721_ tree_instances\[8\].u_tree.frame_id_out\[3\] tree_instances\[8\].u_tree.pipeline_frame_id\[0\]\[3\]
+ _1668_ VGND VGND VPWR VPWR _1198_ sky130_fd_sc_hd__mux2_1
XFILLER_0_23_98 VPWR VGND VPWR VGND sky130_ef_sc_hd__decap_12
XFILLER_0_82_194 VGND VGND VPWR VPWR sky130_fd_sc_hd__fill_2
XFILLER_0_70_334 VGND VGND VPWR VPWR sky130_fd_sc_hd__fill_2
X_3652_ _1159_ VGND VGND VPWR VPWR _0280_ sky130_fd_sc_hd__clkbuf_1
XFILLER_0_15_228 VGND VGND VPWR VPWR sky130_fd_sc_hd__fill_2
XFILLER_0_43_537 VGND VGND VPWR VPWR sky130_fd_sc_hd__fill_1
XFILLER_0_43_559 VGND VGND VPWR VPWR sky130_fd_sc_hd__fill_1
X_3583_ _1113_ VGND VGND VPWR VPWR _0257_ sky130_fd_sc_hd__clkbuf_1
X_2603_ tree_instances\[1\].u_tree.tree_state\[0\] _1933_ VGND VGND VPWR VPWR _1934_
+ sky130_fd_sc_hd__nand2_1
XANTENNA__4635__RESET_B tree_instances\[0\].u_tree.rst_n VGND VGND VPWR VPWR sky130_fd_sc_hd__diode_2
XFILLER_0_2_133 VGND VGND VPWR VPWR sky130_fd_sc_hd__fill_1
X_2534_ tree_instances\[2\].u_tree.pipeline_current_node\[0\]\[1\] _1874_ VGND VGND
+ VPWR VPWR _1875_ sky130_fd_sc_hd__or2_1
X_2465_ tree_instances\[4\].u_tree.pipeline_current_node\[0\]\[4\] VGND VGND VPWR
+ VPWR _1816_ sky130_fd_sc_hd__clkbuf_1
X_2396_ _1561_ VGND VGND VPWR VPWR _1754_ sky130_fd_sc_hd__clkbuf_1
X_4204_ _1483_ VGND VGND VPWR VPWR _0508_ sky130_fd_sc_hd__clkbuf_1
X_4135_ _2148_ VGND VGND VPWR VPWR _1440_ sky130_fd_sc_hd__clkbuf_1
XFILLER_0_3_53 VGND VGND VPWR VPWR sky130_fd_sc_hd__decap_3
Xwire10 net13 VGND VGND VPWR VPWR net10 sky130_fd_sc_hd__clkbuf_16
X_4066_ tree_instances\[15\].u_tree.frame_id_out\[4\] tree_instances\[15\].u_tree.pipeline_frame_id\[0\]\[4\]
+ tree_instances\[15\].u_tree.tree_state\[3\] VGND VGND VPWR VPWR _1395_ sky130_fd_sc_hd__mux2_1
X_3017_ current_voting_frame\[3\] VGND VGND VPWR VPWR _0689_ sky130_fd_sc_hd__inv_2
XTAP_TAPCELL_ROW_54_749 VGND VPWR sky130_fd_sc_hd__tapvpwrvgnd_1
XFILLER_0_58_180 VGND VGND VPWR VPWR sky130_fd_sc_hd__fill_2
XFILLER_0_19_545 VPWR VGND VPWR VGND sky130_ef_sc_hd__decap_12
XFILLER_0_73_150 VGND VGND VPWR VPWR sky130_fd_sc_hd__fill_1
X_3919_ tree_instances\[12\].u_tree.frame_id_out\[3\] tree_instances\[12\].u_tree.pipeline_frame_id\[0\]\[3\]
+ _1579_ VGND VGND VPWR VPWR _1312_ sky130_fd_sc_hd__mux2_1
XANTENNA_clkbuf_3_2__f_clk_A clknet_0_clk VGND VGND VPWR VPWR sky130_fd_sc_hd__diode_2
XANTENNA__4376__RESET_B net13 VGND VGND VPWR VPWR sky130_fd_sc_hd__diode_2
XFILLER_0_61_367 VGND VGND VPWR VPWR sky130_fd_sc_hd__decap_4
XFILLER_0_69_445 VGND VGND VPWR VPWR sky130_fd_sc_hd__decap_3
XFILLER_0_96_253 VPWR VGND VPWR VGND sky130_ef_sc_hd__decap_12
XPHY_EDGE_ROW_69_Right_69 VGND VGND VPWR VPWR sky130_fd_sc_hd__decap_3
XTAP_TAPCELL_ROW_25_462 VGND VPWR sky130_fd_sc_hd__tapvpwrvgnd_1
XFILLER_0_37_342 VGND VGND VPWR VPWR sky130_fd_sc_hd__fill_2
XFILLER_0_4_409 VGND VGND VPWR VPWR sky130_fd_sc_hd__decap_8
XFILLER_0_25_559 VGND VGND VPWR VPWR sky130_fd_sc_hd__fill_1
XFILLER_0_12_209 VGND VGND VPWR VPWR sky130_fd_sc_hd__decap_4
XANTENNA__3019__A _0690_ VGND VGND VPWR VPWR sky130_fd_sc_hd__diode_2
XPHY_EDGE_ROW_78_Right_78 VGND VGND VPWR VPWR sky130_fd_sc_hd__decap_3
XFILLER_0_20_253 VGND VGND VPWR VPWR sky130_fd_sc_hd__decap_4
XFILLER_0_85_38 VPWR VGND VPWR VGND sky130_ef_sc_hd__decap_12
X_2250_ _1624_ _1625_ VGND VGND VPWR VPWR _1626_ sky130_fd_sc_hd__nor2_1
X_2181_ _1563_ VGND VGND VPWR VPWR _1564_ sky130_fd_sc_hd__clkbuf_1
XFILLER_0_34_20 VGND VGND VPWR VPWR sky130_fd_sc_hd__decap_8
XPHY_EDGE_ROW_87_Right_87 VGND VGND VPWR VPWR sky130_fd_sc_hd__decap_3
XFILLER_0_87_264 VPWR VGND VPWR VGND sky130_ef_sc_hd__decap_12
XTAP_TAPCELL_ROW_51_719 VGND VPWR sky130_fd_sc_hd__tapvpwrvgnd_1
XANTENNA__4887__RESET_B net11 VGND VGND VPWR VPWR sky130_fd_sc_hd__diode_2
X_4822_ clknet_leaf_50_clk _0504_ net10 VGND VGND VPWR VPWR tree_instances\[18\].u_tree.pipeline_current_node\[0\]\[0\]
+ sky130_fd_sc_hd__dfrtp_1
XFILLER_0_62_109 VPWR VGND VPWR VGND sky130_ef_sc_hd__decap_12
XFILLER_0_7_225 VPWR VGND VPWR VGND sky130_ef_sc_hd__decap_12
XANTENNA__4816__RESET_B net12 VGND VGND VPWR VPWR sky130_fd_sc_hd__diode_2
X_4753_ clknet_leaf_46_clk _0450_ net10 VGND VGND VPWR VPWR tree_instances\[15\].u_tree.pipeline_frame_id\[0\]\[0\]
+ sky130_fd_sc_hd__dfrtp_1
XFILLER_0_50_41 VPWR VGND VPWR VGND sky130_ef_sc_hd__decap_12
XFILLER_0_55_161 VGND VGND VPWR VPWR sky130_fd_sc_hd__fill_2
X_3704_ tree_instances\[8\].u_tree.pipeline_frame_id\[0\]\[0\] _1162_ _0040_ VGND
+ VGND VPWR VPWR _1189_ sky130_fd_sc_hd__mux2_1
XFILLER_0_50_85 VPWR VGND VPWR VGND sky130_ef_sc_hd__decap_12
XFILLER_0_55_194 VGND VGND VPWR VPWR sky130_fd_sc_hd__fill_2
X_4684_ clknet_leaf_19_clk _0388_ net11 VGND VGND VPWR VPWR tree_instances\[12\].u_tree.pipeline_frame_id\[0\]\[1\]
+ sky130_fd_sc_hd__dfrtp_1
XPHY_EDGE_ROW_96_Right_96 VGND VGND VPWR VPWR sky130_fd_sc_hd__decap_3
XFILLER_0_70_197 VGND VGND VPWR VPWR sky130_fd_sc_hd__fill_2
X_3635_ _1146_ _1139_ VGND VGND VPWR VPWR _1147_ sky130_fd_sc_hd__and2_1
X_3566_ _1099_ VGND VGND VPWR VPWR _1100_ sky130_fd_sc_hd__clkbuf_1
XFILLER_0_3_497 VGND VGND VPWR VPWR sky130_fd_sc_hd__decap_6
X_2517_ _1722_ VGND VGND VPWR VPWR _1862_ sky130_fd_sc_hd__clkbuf_1
X_3497_ _1053_ VGND VGND VPWR VPWR _1054_ sky130_fd_sc_hd__dlymetal6s2s_1
XFILLER_0_11_286 VGND VGND VPWR VPWR sky130_fd_sc_hd__fill_2
X_2448_ tree_instances\[10\].u_tree.pipeline_current_node\[0\]\[3\] VGND VGND VPWR
+ VPWR _1801_ sky130_fd_sc_hd__clkbuf_1
XFILLER_0_52_3 VGND VGND VPWR VPWR sky130_fd_sc_hd__decap_8
X_2379_ _1739_ VGND VGND VPWR VPWR _1740_ sky130_fd_sc_hd__clkbuf_1
XFILLER_0_75_71 VGND VGND VPWR VPWR sky130_fd_sc_hd__fill_2
X_4118_ tree_instances\[18\].u_tree.pipeline_current_node\[0\]\[3\] VGND VGND VPWR
+ VPWR _1424_ sky130_fd_sc_hd__clkbuf_1
XTAP_TAPCELL_ROW_67_874 VGND VPWR sky130_fd_sc_hd__tapvpwrvgnd_1
X_4049_ _1386_ VGND VGND VPWR VPWR _0450_ sky130_fd_sc_hd__clkbuf_1
XFILLER_0_78_253 VGND VGND VPWR VPWR sky130_fd_sc_hd__decap_3
XTAP_TAPCELL_ROW_39_598 VGND VPWR sky130_fd_sc_hd__tapvpwrvgnd_1
XFILLER_0_91_81 VPWR VGND VPWR VGND sky130_ef_sc_hd__decap_12
XFILLER_0_38_117 VGND VGND VPWR VPWR sky130_fd_sc_hd__fill_1
XFILLER_0_93_234 VGND VGND VPWR VPWR sky130_fd_sc_hd__fill_1
XFILLER_0_66_448 VGND VGND VPWR VPWR sky130_fd_sc_hd__decap_4
XFILLER_0_81_418 VGND VGND VPWR VPWR sky130_fd_sc_hd__fill_2
XFILLER_0_81_407 VGND VGND VPWR VPWR sky130_fd_sc_hd__fill_2
XANTENNA__4557__RESET_B net9 VGND VGND VPWR VPWR sky130_fd_sc_hd__diode_2
XTAP_TAPCELL_ROW_22_432 VGND VPWR sky130_fd_sc_hd__tapvpwrvgnd_1
XFILLER_0_46_161 VPWR VGND VPWR VGND sky130_ef_sc_hd__decap_12
XFILLER_0_34_345 VGND VGND VPWR VPWR sky130_fd_sc_hd__decap_4
XFILLER_0_30_540 VPWR VGND VPWR VGND sky130_ef_sc_hd__decap_12
XFILLER_0_69_231 VPWR VGND VPWR VGND sky130_ef_sc_hd__decap_12
XANTENNA__3798__A1 _1162_ VGND VGND VPWR VPWR sky130_fd_sc_hd__diode_2
XFILLER_0_69_297 VPWR VGND VPWR VGND sky130_ef_sc_hd__decap_12
XFILLER_0_72_418 VGND VGND VPWR VPWR sky130_fd_sc_hd__fill_2
XFILLER_0_25_301 VGND VGND VPWR VPWR sky130_fd_sc_hd__fill_2
XFILLER_0_44_109 VGND VGND VPWR VPWR sky130_fd_sc_hd__fill_2
XFILLER_0_80_440 VGND VGND VPWR VPWR sky130_fd_sc_hd__decap_3
XFILLER_0_25_345 VGND VGND VPWR VPWR sky130_fd_sc_hd__fill_2
XFILLER_0_13_529 VPWR VGND VPWR VGND sky130_ef_sc_hd__decap_12
XFILLER_0_20_66 VPWR VGND VPWR VGND sky130_ef_sc_hd__decap_12
XANTENNA__3970__A1 _1168_ VGND VGND VPWR VPWR sky130_fd_sc_hd__diode_2
XFILLER_0_40_326 VGND VGND VPWR VPWR sky130_fd_sc_hd__decap_8
XFILLER_0_96_15 VPWR VGND VPWR VGND sky130_ef_sc_hd__decap_12
X_3420_ tree_instances\[3\].u_tree.pipeline_frame_id\[0\]\[2\] _0675_ _0030_ VGND
+ VGND VPWR VPWR _1008_ sky130_fd_sc_hd__mux2_1
X_3351_ tree_instances\[2\].u_tree.pipeline_current_node\[0\]\[3\] VGND VGND VPWR
+ VPWR _0968_ sky130_fd_sc_hd__clkbuf_1
XFILLER_0_21_573 VGND VGND VPWR VPWR sky130_fd_sc_hd__fill_1
XFILLER_0_0_489 VPWR VGND VPWR VGND sky130_ef_sc_hd__decap_12
X_2302_ tree_instances\[18\].u_tree.tree_state\[0\] _1669_ _1670_ VGND VGND VPWR VPWR
+ _0060_ sky130_fd_sc_hd__a21o_1
X_3282_ tree_instances\[0\].u_tree.frame_id_out\[1\] tree_instances\[0\].u_tree.pipeline_frame_id\[0\]\[1\]
+ _1832_ VGND VGND VPWR VPWR _0929_ sky130_fd_sc_hd__mux2_1
XFILLER_0_29_64 VPWR VGND VPWR VGND sky130_ef_sc_hd__decap_12
X_2233_ _1609_ VGND VGND VPWR VPWR _1610_ sky130_fd_sc_hd__clkbuf_1
X_2164_ tree_instances\[3\].u_tree.ready_for_next tree_instances\[2\].u_tree.ready_for_next
+ tree_instances\[5\].u_tree.ready_for_next tree_instances\[4\].u_tree.ready_for_next
+ VGND VGND VPWR VPWR _1548_ sky130_fd_sc_hd__and4_1
XTAP_TAPCELL_ROW_88_1087 VGND VPWR sky130_fd_sc_hd__tapvpwrvgnd_1
XTAP_TAPCELL_ROW_64_844 VGND VPWR sky130_fd_sc_hd__tapvpwrvgnd_1
XFILLER_0_88_573 VGND VGND VPWR VPWR sky130_fd_sc_hd__fill_1
XTAP_TAPCELL_ROW_36_568 VGND VPWR sky130_fd_sc_hd__tapvpwrvgnd_1
XFILLER_0_75_223 VGND VGND VPWR VPWR sky130_fd_sc_hd__fill_1
XFILLER_0_8_501 VPWR VGND VPWR VGND sky130_ef_sc_hd__decap_12
XFILLER_0_8_545 VPWR VGND VPWR VGND sky130_ef_sc_hd__decap_12
XANTENNA__4650__RESET_B net9 VGND VGND VPWR VPWR sky130_fd_sc_hd__diode_2
X_4805_ clknet_leaf_46_clk _0492_ net11 VGND VGND VPWR VPWR tree_instances\[17\].u_tree.pipeline_frame_id\[0\]\[0\]
+ sky130_fd_sc_hd__dfrtp_1
XFILLER_0_90_237 VGND VGND VPWR VPWR sky130_fd_sc_hd__decap_6
X_2997_ _0672_ VGND VGND VPWR VPWR _0673_ sky130_fd_sc_hd__clkbuf_4
XFILLER_0_16_312 VGND VGND VPWR VPWR sky130_fd_sc_hd__fill_2
X_4736_ clknet_leaf_30_clk _0434_ net11 VGND VGND VPWR VPWR tree_instances\[14\].u_tree.frame_id_out\[0\]
+ sky130_fd_sc_hd__dfrtp_1
X_4667_ clknet_leaf_11_clk _0372_ tree_instances\[0\].u_tree.rst_n VGND VGND VPWR
+ VPWR tree_instances\[11\].u_tree.frame_id_out\[1\] sky130_fd_sc_hd__dfrtp_1
X_3618_ _1752_ VGND VGND VPWR VPWR _1134_ sky130_fd_sc_hd__inv_2
XFILLER_0_31_337 VGND VGND VPWR VPWR sky130_fd_sc_hd__decap_8
XANTENNA__3713__A1 _1168_ VGND VGND VPWR VPWR sky130_fd_sc_hd__diode_2
X_4598_ clknet_leaf_63_clk _0072_ net9 VGND VGND VPWR VPWR tree_instances\[4\].u_tree.tree_state\[3\]
+ sky130_fd_sc_hd__dfrtp_1
XFILLER_0_12_573 VGND VGND VPWR VPWR sky130_fd_sc_hd__fill_1
X_3549_ tree_instances\[5\].u_tree.frame_id_out\[4\] tree_instances\[5\].u_tree.pipeline_frame_id\[0\]\[4\]
+ tree_instances\[5\].u_tree.tree_state\[3\] VGND VGND VPWR VPWR _1088_ sky130_fd_sc_hd__mux2_1
XANTENNA__4370__SET_B net12 VGND VGND VPWR VPWR sky130_fd_sc_hd__diode_2
XANTENNA__4738__RESET_B net11 VGND VGND VPWR VPWR sky130_fd_sc_hd__diode_2
XFILLER_0_66_201 VPWR VGND VPWR VGND sky130_ef_sc_hd__decap_12
XFILLER_0_66_245 VGND VGND VPWR VPWR sky130_fd_sc_hd__decap_6
XANTENNA__4391__RESET_B net13 VGND VGND VPWR VPWR sky130_fd_sc_hd__diode_2
XFILLER_0_26_109 VGND VGND VPWR VPWR sky130_fd_sc_hd__fill_2
XFILLER_0_81_237 VGND VGND VPWR VPWR sky130_fd_sc_hd__fill_1
XFILLER_0_81_215 VGND VGND VPWR VPWR sky130_fd_sc_hd__decap_8
XANTENNA_clkbuf_leaf_22_clk_A clknet_3_3__leaf_clk VGND VGND VPWR VPWR sky130_fd_sc_hd__diode_2
XFILLER_0_34_120 VPWR VGND VPWR VGND sky130_ef_sc_hd__decap_12
XFILLER_0_62_495 VGND VGND VPWR VPWR sky130_fd_sc_hd__fill_1
XFILLER_0_62_462 VGND VGND VPWR VPWR sky130_fd_sc_hd__fill_2
XFILLER_0_34_164 VGND VGND VPWR VPWR sky130_fd_sc_hd__fill_2
XANTENNA_clkbuf_leaf_37_clk_A clknet_3_7__leaf_clk VGND VGND VPWR VPWR sky130_fd_sc_hd__diode_2
XANTENNA__3704__A1 _1162_ VGND VGND VPWR VPWR sky130_fd_sc_hd__diode_2
XFILLER_0_66_18 VGND VGND VPWR VPWR sky130_fd_sc_hd__decap_6
XFILLER_0_66_29 VPWR VGND VPWR VGND sky130_ef_sc_hd__decap_12
XTAP_TAPCELL_ROW_7_282 VGND VPWR sky130_fd_sc_hd__tapvpwrvgnd_1
XFILLER_0_89_337 VPWR VGND VPWR VGND sky130_ef_sc_hd__decap_12
XANTENNA_clkload1_A clknet_3_3__leaf_clk VGND VGND VPWR VPWR sky130_fd_sc_hd__diode_2
XFILLER_0_15_55 VGND VGND VPWR VPWR sky130_fd_sc_hd__fill_1
XANTENNA__4479__RESET_B net9 VGND VGND VPWR VPWR sky130_fd_sc_hd__diode_2
XANTENNA__4408__RESET_B net13 VGND VGND VPWR VPWR sky130_fd_sc_hd__diode_2
XFILLER_0_85_554 VGND VGND VPWR VPWR sky130_fd_sc_hd__decap_6
XTAP_TAPCELL_ROW_61_814 VGND VPWR sky130_fd_sc_hd__tapvpwrvgnd_1
XFILLER_0_57_223 VGND VGND VPWR VPWR sky130_fd_sc_hd__fill_1
X_2920_ _0617_ _1596_ VGND VGND VPWR VPWR _0618_ sky130_fd_sc_hd__or2_1
XTAP_TAPCELL_ROW_33_538 VGND VPWR sky130_fd_sc_hd__tapvpwrvgnd_1
X_2851_ _2153_ VGND VGND VPWR VPWR _0095_ sky130_fd_sc_hd__clkbuf_1
X_2782_ tree_instances\[15\].u_tree.prediction_valid _1936_ VGND VGND VPWR VPWR _2089_
+ sky130_fd_sc_hd__and2b_1
XFILLER_0_5_559 VGND VGND VPWR VPWR sky130_fd_sc_hd__fill_1
XFILLER_0_31_87 VGND VGND VPWR VPWR sky130_fd_sc_hd__fill_1
X_4521_ clknet_leaf_4_clk _0251_ tree_instances\[0\].u_tree.rst_n VGND VGND VPWR VPWR
+ tree_instances\[10\].u_tree.pipeline_valid\[0\] sky130_fd_sc_hd__dfrtp_1
XFILLER_0_80_292 VPWR VGND VPWR VGND sky130_ef_sc_hd__decap_12
XFILLER_0_13_337 VGND VGND VPWR VPWR sky130_fd_sc_hd__decap_3
X_4452_ clknet_leaf_69_clk _0193_ net9 VGND VGND VPWR VPWR tree_instances\[3\].u_tree.pipeline_current_node\[0\]\[4\]
+ sky130_fd_sc_hd__dfrtp_1
X_3403_ _0999_ VGND VGND VPWR VPWR _0191_ sky130_fd_sc_hd__clkbuf_1
XFILLER_0_40_167 VPWR VGND VPWR VGND sky130_ef_sc_hd__decap_12
X_4383_ clknet_leaf_36_clk _0131_ net10 VGND VGND VPWR VPWR tree_instances\[0\].u_tree.pipeline_current_node\[0\]\[5\]
+ sky130_fd_sc_hd__dfrtp_1
XFILLER_0_0_253 VPWR VGND VPWR VGND sky130_ef_sc_hd__decap_12
XFILLER_0_40_189 VGND VGND VPWR VPWR sky130_fd_sc_hd__decap_4
XANTENNA__3207__A _0660_ VGND VGND VPWR VPWR sky130_fd_sc_hd__diode_2
X_3334_ tree_instances\[1\].u_tree.tree_state\[3\] _1934_ _0638_ tree_instances\[1\].u_tree.ready_for_next
+ VGND VGND VPWR VPWR _0166_ sky130_fd_sc_hd__a22o_1
XTAP_TAPCELL_ROW_69_903 VGND VPWR sky130_fd_sc_hd__tapvpwrvgnd_1
X_3265_ _2130_ _0911_ VGND VGND VPWR VPWR _0920_ sky130_fd_sc_hd__and2_1
XANTENNA__4443__SET_B net9 VGND VGND VPWR VPWR sky130_fd_sc_hd__diode_2
X_2216_ tree_instances\[11\].u_tree.tree_state\[3\] VGND VGND VPWR VPWR _1595_ sky130_fd_sc_hd__buf_2
X_3196_ current_voting_frame\[3\] tree_instances\[13\].u_tree.frame_id_out\[3\] VGND
+ VGND VPWR VPWR _0868_ sky130_fd_sc_hd__and2_1
XTAP_TAPCELL_ROW_77_980 VGND VPWR sky130_fd_sc_hd__tapvpwrvgnd_1
XFILLER_0_15_3 VPWR VGND VPWR VGND sky130_ef_sc_hd__decap_12
XANTENNA__4831__RESET_B net13 VGND VGND VPWR VPWR sky130_fd_sc_hd__diode_2
XFILLER_0_48_201 VPWR VGND VPWR VGND sky130_ef_sc_hd__decap_12
XFILLER_0_91_502 VGND VGND VPWR VPWR sky130_fd_sc_hd__fill_2
XFILLER_0_76_565 VGND VGND VPWR VPWR sky130_fd_sc_hd__decap_8
XFILLER_0_48_267 VGND VGND VPWR VPWR sky130_fd_sc_hd__decap_8
XFILLER_0_63_237 VPWR VGND VPWR VGND sky130_ef_sc_hd__decap_12
X_4719_ clknet_leaf_56_clk _0028_ tree_instances\[0\].u_tree.rst_n VGND VGND VPWR
+ VPWR tree_instances\[2\].u_tree.tree_state\[2\] sky130_fd_sc_hd__dfrtp_1
XFILLER_0_16_175 VPWR VGND VPWR VGND sky130_ef_sc_hd__decap_12
XFILLER_0_71_281 VGND VGND VPWR VPWR sky130_fd_sc_hd__fill_1
XFILLER_0_16_197 VGND VGND VPWR VPWR sky130_fd_sc_hd__decap_4
XTAP_TAPCELL_ROW_4_252 VGND VPWR sky130_fd_sc_hd__tapvpwrvgnd_1
XFILLER_0_67_532 VGND VGND VPWR VPWR sky130_fd_sc_hd__decap_3
XANTENNA__4501__RESET_B tree_instances\[0\].u_tree.rst_n VGND VGND VPWR VPWR sky130_fd_sc_hd__diode_2
XFILLER_0_39_223 VGND VGND VPWR VPWR sky130_fd_sc_hd__fill_1
XFILLER_0_39_234 VGND VGND VPWR VPWR sky130_fd_sc_hd__decap_4
XFILLER_0_27_418 VGND VGND VPWR VPWR sky130_fd_sc_hd__decap_6
XFILLER_0_39_278 VGND VGND VPWR VPWR sky130_fd_sc_hd__fill_2
XTAP_TAPCELL_ROW_30_508 VGND VPWR sky130_fd_sc_hd__tapvpwrvgnd_1
XANTENNA__4178__A1 tree_instances\[0\].u_tree.frame_id_in\[4\] VGND VGND VPWR VPWR
+ sky130_fd_sc_hd__diode_2
XFILLER_0_10_307 VGND VGND VPWR VPWR sky130_fd_sc_hd__fill_1
XFILLER_0_50_454 VPWR VGND VPWR VGND sky130_ef_sc_hd__decap_12
XFILLER_0_10_318 VPWR VGND VPWR VGND sky130_ef_sc_hd__decap_12
XFILLER_0_93_27 VGND VGND VPWR VPWR sky130_fd_sc_hd__decap_4
X_3050_ _0686_ tree_instances\[15\].u_tree.frame_id_out\[1\] tree_instances\[15\].u_tree.frame_id_out\[4\]
+ _0697_ VGND VGND VPWR VPWR _0722_ sky130_fd_sc_hd__o22a_1
XFILLER_0_89_156 VPWR VGND VPWR VGND sky130_ef_sc_hd__decap_12
XFILLER_0_26_65 VGND VGND VPWR VPWR sky130_fd_sc_hd__decap_8
XTAP_TAPCELL_ROW_74_950 VGND VPWR sky130_fd_sc_hd__tapvpwrvgnd_1
XTAP_TAPCELL_ROW_85_1057 VGND VPWR sky130_fd_sc_hd__tapvpwrvgnd_1
X_3952_ _1996_ _1332_ VGND VGND VPWR VPWR _1337_ sky130_fd_sc_hd__and2_1
XTAP_TAPCELL_ROW_18_387 VGND VPWR sky130_fd_sc_hd__tapvpwrvgnd_1
XFILLER_0_18_418 VGND VGND VPWR VPWR sky130_fd_sc_hd__fill_2
X_3883_ tree_instances\[12\].u_tree.tree_state\[2\] tree_instances\[12\].u_tree.tree_state\[1\]
+ _0606_ VGND VGND VPWR VPWR _1293_ sky130_fd_sc_hd__or3_1
X_2903_ _0606_ VGND VGND VPWR VPWR _0008_ sky130_fd_sc_hd__inv_2
X_2834_ tree_instances\[20\].u_tree.pipeline_current_node\[0\]\[6\] VGND VGND VPWR
+ VPWR _2137_ sky130_fd_sc_hd__clkbuf_1
X_2765_ _2072_ VGND VGND VPWR VPWR _2073_ sky130_fd_sc_hd__clkbuf_1
X_4504_ clknet_leaf_52_clk _0235_ net13 VGND VGND VPWR VPWR tree_instances\[5\].u_tree.pipeline_current_node\[0\]\[4\]
+ sky130_fd_sc_hd__dfrtp_1
XFILLER_0_41_421 VGND VGND VPWR VPWR sky130_fd_sc_hd__fill_2
XFILLER_0_53_281 VGND VGND VPWR VPWR sky130_fd_sc_hd__fill_2
XTAP_TAPCELL_ROW_96_1175 VGND VPWR sky130_fd_sc_hd__tapvpwrvgnd_1
XTAP_TAPCELL_ROW_96_1164 VGND VPWR sky130_fd_sc_hd__tapvpwrvgnd_1
X_2696_ _2013_ VGND VGND VPWR VPWR _2015_ sky130_fd_sc_hd__clkbuf_1
X_4435_ clknet_leaf_57_clk _0181_ net13 VGND VGND VPWR VPWR tree_instances\[2\].u_tree.pipeline_frame_id\[0\]\[4\]
+ sky130_fd_sc_hd__dfrtp_1
XFILLER_0_6_53 VPWR VGND VPWR VGND sky130_ef_sc_hd__decap_12
XFILLER_0_1_573 VGND VGND VPWR VPWR sky130_fd_sc_hd__fill_1
X_4366_ clknet_leaf_8_clk _0081_ net12 VGND VGND VPWR VPWR tree_instances\[9\].u_tree.tree_state\[0\]
+ sky130_fd_sc_hd__dfstp_1
X_3317_ _0947_ VGND VGND VPWR VPWR _0157_ sky130_fd_sc_hd__clkbuf_1
XFILLER_0_67_83 VGND VGND VPWR VPWR sky130_fd_sc_hd__fill_2
X_4297_ _1531_ VGND VGND VPWR VPWR _0553_ sky130_fd_sc_hd__clkbuf_1
X_3248_ _0662_ _0908_ VGND VGND VPWR VPWR _0125_ sky130_fd_sc_hd__xnor2_1
XTAP_TAPCELL_ROW_1_222 VGND VPWR sky130_fd_sc_hd__tapvpwrvgnd_1
X_3179_ _0733_ _0848_ tree_instances\[20\].u_tree.prediction_valid _0849_ _0850_ VGND
+ VGND VPWR VPWR _0851_ sky130_fd_sc_hd__o2111a_1
XFILLER_0_76_340 VPWR VGND VPWR VGND sky130_ef_sc_hd__decap_12
XFILLER_0_36_237 VGND VGND VPWR VPWR sky130_fd_sc_hd__fill_2
XFILLER_0_91_365 VGND VGND VPWR VPWR sky130_fd_sc_hd__decap_3
XANTENNA__3907__A1 _1165_ VGND VGND VPWR VPWR sky130_fd_sc_hd__diode_2
XFILLER_0_32_421 VGND VGND VPWR VPWR sky130_fd_sc_hd__decap_3
XTAP_TAPCELL_ROW_9_300 VGND VPWR sky130_fd_sc_hd__tapvpwrvgnd_1
XANTENNA__4753__RESET_B net10 VGND VGND VPWR VPWR sky130_fd_sc_hd__diode_2
XFILLER_0_86_126 VPWR VGND VPWR VGND sky130_ef_sc_hd__decap_12
XTAP_TAPCELL_ROW_71_920 VGND VPWR sky130_fd_sc_hd__tapvpwrvgnd_1
XTAP_TAPCELL_ROW_15_357 VGND VPWR sky130_fd_sc_hd__tapvpwrvgnd_1
XANTENNA__3071__B2 _0690_ VGND VGND VPWR VPWR sky130_fd_sc_hd__diode_2
XFILLER_0_6_109 VGND VGND VPWR VPWR sky130_fd_sc_hd__fill_2
XFILLER_0_82_365 VGND VGND VPWR VPWR sky130_fd_sc_hd__fill_1
XFILLER_0_82_398 VGND VGND VPWR VPWR sky130_fd_sc_hd__fill_2
XFILLER_0_35_270 VGND VGND VPWR VPWR sky130_fd_sc_hd__decap_8
XFILLER_0_35_281 VPWR VGND VPWR VGND sky130_ef_sc_hd__decap_12
X_2550_ tree_instances\[14\].u_tree.tree_state\[0\] _1888_ _1889_ VGND VGND VPWR VPWR
+ _0052_ sky130_fd_sc_hd__a21o_1
XFILLER_0_23_465 VGND VGND VPWR VPWR sky130_fd_sc_hd__fill_1
XFILLER_0_50_251 VGND VGND VPWR VPWR sky130_fd_sc_hd__fill_1
XFILLER_0_10_115 VGND VGND VPWR VPWR sky130_fd_sc_hd__decap_3
X_2481_ _1827_ _1829_ VGND VGND VPWR VPWR _1830_ sky130_fd_sc_hd__or2_1
XANTENNA__4323__A1 net1 VGND VGND VPWR VPWR sky130_fd_sc_hd__diode_2
X_4220_ _1491_ VGND VGND VPWR VPWR _0516_ sky130_fd_sc_hd__clkbuf_1
XFILLER_0_50_295 VGND VGND VPWR VPWR sky130_fd_sc_hd__fill_1
X_4151_ _1452_ _1444_ VGND VGND VPWR VPWR _1453_ sky130_fd_sc_hd__and2_1
XANTENNA__4494__RESET_B net11 VGND VGND VPWR VPWR sky130_fd_sc_hd__diode_2
X_3102_ _0662_ _0773_ tree_instances\[0\].u_tree.prediction_valid VGND VGND VPWR VPWR
+ _0774_ sky130_fd_sc_hd__o21ai_1
X_4082_ _2066_ _1399_ VGND VGND VPWR VPWR _1404_ sky130_fd_sc_hd__and2_1
XFILLER_0_37_75 VGND VGND VPWR VPWR sky130_fd_sc_hd__decap_3
XANTENNA__4423__RESET_B tree_instances\[0\].u_tree.rst_n VGND VGND VPWR VPWR sky130_fd_sc_hd__diode_2
X_3033_ _0704_ tree_instances\[7\].u_tree.frame_id_out\[2\] VGND VGND VPWR VPWR _0705_
+ sky130_fd_sc_hd__and2_1
XANTENNA__3204__B _0650_ VGND VGND VPWR VPWR sky130_fd_sc_hd__diode_2
XFILLER_0_73_310 VGND VGND VPWR VPWR sky130_fd_sc_hd__decap_8
X_3935_ tree_instances\[15\].u_tree.pipeline_current_node\[0\]\[6\] VGND VGND VPWR
+ VPWR _1325_ sky130_fd_sc_hd__clkbuf_1
XFILLER_0_85_181 VPWR VGND VPWR VGND sky130_ef_sc_hd__decap_12
XFILLER_0_73_321 VGND VGND VPWR VPWR sky130_fd_sc_hd__decap_4
XFILLER_0_46_557 VGND VGND VPWR VPWR sky130_fd_sc_hd__decap_6
X_3866_ _1750_ _1276_ _0036_ tree_instances\[6\].u_tree.pipeline_valid\[0\] VGND VGND
+ VPWR VPWR _0377_ sky130_fd_sc_hd__o2bb2a_1
XFILLER_0_61_505 VGND VGND VPWR VPWR sky130_fd_sc_hd__fill_1
XFILLER_0_5_131 VPWR VGND VPWR VGND sky130_ef_sc_hd__decap_12
XFILLER_0_82_3 VGND VGND VPWR VPWR sky130_fd_sc_hd__decap_8
XFILLER_0_14_421 VPWR VGND VPWR VGND sky130_ef_sc_hd__decap_12
X_2817_ _2120_ VGND VGND VPWR VPWR _2121_ sky130_fd_sc_hd__clkbuf_1
X_3797_ _1241_ VGND VGND VPWR VPWR _0343_ sky130_fd_sc_hd__clkbuf_1
XFILLER_0_5_186 VGND VGND VPWR VPWR sky130_fd_sc_hd__fill_1
X_2748_ _1789_ VGND VGND VPWR VPWR _2059_ sky130_fd_sc_hd__clkbuf_1
XANTENNA__2573__B1 _1908_ VGND VGND VPWR VPWR sky130_fd_sc_hd__diode_2
X_4418_ clknet_leaf_20_clk _0165_ net11 VGND VGND VPWR VPWR tree_instances\[1\].u_tree.frame_id_out\[4\]
+ sky130_fd_sc_hd__dfrtp_1
X_2679_ _1999_ VGND VGND VPWR VPWR _2000_ sky130_fd_sc_hd__clkbuf_1
X_4349_ clknet_leaf_16_clk _0109_ net12 VGND VGND VPWR VPWR net5 sky130_fd_sc_hd__dfrtp_1
XFILLER_0_94_92 VPWR VGND VPWR VGND sky130_ef_sc_hd__decap_12
XANTENNA__3053__A1 _0685_ VGND VGND VPWR VPWR sky130_fd_sc_hd__diode_2
XTAP_TAPCELL_ROW_12_327 VGND VPWR sky130_fd_sc_hd__tapvpwrvgnd_1
XANTENNA__3053__B2 _0704_ VGND VGND VPWR VPWR sky130_fd_sc_hd__diode_2
XFILLER_0_64_365 VPWR VGND VPWR VGND sky130_ef_sc_hd__decap_12
XFILLER_0_24_207 VGND VGND VPWR VPWR sky130_fd_sc_hd__fill_1
XFILLER_0_32_273 VGND VGND VPWR VPWR sky130_fd_sc_hd__fill_2
XFILLER_0_87_402 VGND VGND VPWR VPWR sky130_fd_sc_hd__decap_4
XFILLER_0_87_435 VPWR VGND VPWR VGND sky130_ef_sc_hd__decap_12
XTAP_TAPCELL_ROW_82_1027 VGND VPWR sky130_fd_sc_hd__tapvpwrvgnd_1
XFILLER_0_23_11 VGND VGND VPWR VPWR sky130_fd_sc_hd__fill_2
XTAP_TAPCELL_ROW_28_493 VGND VPWR sky130_fd_sc_hd__tapvpwrvgnd_1
XFILLER_0_28_502 VGND VGND VPWR VPWR sky130_fd_sc_hd__decap_4
XFILLER_0_28_524 VGND VGND VPWR VPWR sky130_fd_sc_hd__fill_1
X_3720_ _1197_ VGND VGND VPWR VPWR _0310_ sky130_fd_sc_hd__clkbuf_1
XFILLER_0_67_192 VGND VGND VPWR VPWR sky130_fd_sc_hd__fill_2
XFILLER_0_23_66 VPWR VGND VPWR VGND sky130_ef_sc_hd__decap_12
Xclkbuf_leaf_40_clk clknet_3_7__leaf_clk VGND VGND VPWR VPWR clknet_leaf_40_clk sky130_fd_sc_hd__clkbuf_4
XFILLER_0_43_505 VGND VGND VPWR VPWR sky130_fd_sc_hd__fill_2
XFILLER_0_55_354 VGND VGND VPWR VPWR sky130_fd_sc_hd__fill_2
XFILLER_0_55_376 VGND VGND VPWR VPWR sky130_fd_sc_hd__fill_2
XFILLER_0_82_173 VGND VGND VPWR VPWR sky130_fd_sc_hd__fill_1
XFILLER_0_70_346 VGND VGND VPWR VPWR sky130_fd_sc_hd__fill_2
X_3651_ _1158_ _1139_ VGND VGND VPWR VPWR _1159_ sky130_fd_sc_hd__and2_1
X_3582_ _1112_ _1096_ VGND VGND VPWR VPWR _1113_ sky130_fd_sc_hd__and2_1
X_2602_ _1575_ tree_instances\[1\].u_tree.pipeline_valid\[0\] VGND VGND VPWR VPWR
+ _1933_ sky130_fd_sc_hd__or2_1
XFILLER_0_11_413 VGND VGND VPWR VPWR sky130_fd_sc_hd__fill_2
X_2533_ tree_instances\[2\].u_tree.pipeline_current_node\[0\]\[0\] VGND VGND VPWR
+ VPWR _1874_ sky130_fd_sc_hd__clkbuf_1
XTAP_TAPCELL_ROW_93_1134 VGND VPWR sky130_fd_sc_hd__tapvpwrvgnd_1
XANTENNA__4675__RESET_B net12 VGND VGND VPWR VPWR sky130_fd_sc_hd__diode_2
X_2464_ _1814_ VGND VGND VPWR VPWR _1815_ sky130_fd_sc_hd__clkbuf_1
X_2395_ _1753_ VGND VGND VPWR VPWR _0075_ sky130_fd_sc_hd__clkbuf_1
XANTENNA__4604__RESET_B net9 VGND VGND VPWR VPWR sky130_fd_sc_hd__diode_2
X_4203_ _1427_ _1478_ VGND VGND VPWR VPWR _1483_ sky130_fd_sc_hd__and2_1
X_4134_ _2143_ VGND VGND VPWR VPWR _1439_ sky130_fd_sc_hd__clkbuf_1
XFILLER_0_3_87 VGND VGND VPWR VPWR sky130_fd_sc_hd__fill_2
X_4065_ _1394_ VGND VGND VPWR VPWR _0458_ sky130_fd_sc_hd__clkbuf_1
X_3016_ tree_instances\[6\].u_tree.frame_id_out\[3\] VGND VGND VPWR VPWR _0688_ sky130_fd_sc_hd__inv_2
XFILLER_0_64_95 VGND VGND VPWR VPWR sky130_fd_sc_hd__fill_2
XFILLER_0_93_427 VGND VGND VPWR VPWR sky130_fd_sc_hd__decap_4
XFILLER_0_65_107 VGND VGND VPWR VPWR sky130_fd_sc_hd__fill_2
XFILLER_0_58_192 VGND VGND VPWR VPWR sky130_fd_sc_hd__fill_2
XFILLER_0_19_557 VGND VGND VPWR VPWR sky130_fd_sc_hd__decap_3
Xclkbuf_leaf_31_clk clknet_3_6__leaf_clk VGND VGND VPWR VPWR clknet_leaf_31_clk sky130_fd_sc_hd__clkbuf_4
X_3918_ _1311_ VGND VGND VPWR VPWR _0394_ sky130_fd_sc_hd__clkbuf_1
XFILLER_0_61_302 VGND VGND VPWR VPWR sky130_fd_sc_hd__decap_3
XFILLER_0_34_505 VGND VGND VPWR VPWR sky130_fd_sc_hd__fill_2
XFILLER_0_46_365 VPWR VGND VPWR VGND sky130_ef_sc_hd__decap_12
XFILLER_0_73_184 VGND VGND VPWR VPWR sky130_fd_sc_hd__fill_2
X_3849_ _1268_ VGND VGND VPWR VPWR _0368_ sky130_fd_sc_hd__clkbuf_1
XFILLER_0_34_549 VGND VGND VPWR VPWR sky130_fd_sc_hd__decap_8
XANTENNA__4345__RESET_B tree_instances\[0\].u_tree.rst_n VGND VGND VPWR VPWR sky130_fd_sc_hd__diode_2
XANTENNA__3125__A _0651_ VGND VGND VPWR VPWR sky130_fd_sc_hd__diode_2
XFILLER_0_96_221 VGND VGND VPWR VPWR sky130_fd_sc_hd__decap_3
XFILLER_0_69_479 VGND VGND VPWR VPWR sky130_fd_sc_hd__decap_8
XFILLER_0_96_265 VPWR VGND VPWR VGND sky130_ef_sc_hd__decap_12
XANTENNA__3026__A1 _0696_ VGND VGND VPWR VPWR sky130_fd_sc_hd__diode_2
XTAP_TAPCELL_ROW_25_463 VGND VPWR sky130_fd_sc_hd__tapvpwrvgnd_1
XFILLER_0_37_310 VGND VGND VPWR VPWR sky130_fd_sc_hd__fill_2
Xclkbuf_leaf_22_clk clknet_3_3__leaf_clk VGND VGND VPWR VPWR clknet_leaf_22_clk sky130_fd_sc_hd__clkbuf_4
XFILLER_0_25_516 VPWR VGND VPWR VGND sky130_ef_sc_hd__decap_12
XFILLER_0_52_357 VGND VGND VPWR VPWR sky130_fd_sc_hd__fill_1
XFILLER_0_20_298 VGND VGND VPWR VPWR sky130_fd_sc_hd__fill_2
X_2180_ _1561_ _1562_ VGND VGND VPWR VPWR _1563_ sky130_fd_sc_hd__or2_1
XFILLER_0_87_276 VGND VGND VPWR VPWR sky130_fd_sc_hd__decap_4
X_4821_ clknet_leaf_21_clk _0503_ net11 VGND VGND VPWR VPWR tree_instances\[1\].u_tree.pipeline_valid\[0\]
+ sky130_fd_sc_hd__dfrtp_1
XFILLER_0_75_427 VGND VGND VPWR VPWR sky130_fd_sc_hd__decap_6
XFILLER_0_75_449 VPWR VGND VPWR VGND sky130_ef_sc_hd__decap_12
XFILLER_0_28_321 VGND VGND VPWR VPWR sky130_fd_sc_hd__decap_4
XFILLER_0_90_408 VGND VGND VPWR VPWR sky130_fd_sc_hd__fill_1
Xclkbuf_leaf_13_clk clknet_3_2__leaf_clk VGND VGND VPWR VPWR clknet_leaf_13_clk sky130_fd_sc_hd__clkbuf_4
XFILLER_0_7_237 VGND VGND VPWR VPWR sky130_fd_sc_hd__decap_4
XFILLER_0_16_505 VPWR VGND VPWR VGND sky130_ef_sc_hd__decap_12
XFILLER_0_28_365 VGND VGND VPWR VPWR sky130_fd_sc_hd__fill_2
X_4752_ clknet_leaf_41_clk _0449_ net10 VGND VGND VPWR VPWR tree_instances\[15\].u_tree.pipeline_current_node\[0\]\[8\]
+ sky130_fd_sc_hd__dfrtp_1
X_3703_ _1188_ VGND VGND VPWR VPWR _0302_ sky130_fd_sc_hd__clkbuf_1
X_4683_ clknet_leaf_14_clk _0387_ net12 VGND VGND VPWR VPWR tree_instances\[12\].u_tree.pipeline_frame_id\[0\]\[0\]
+ sky130_fd_sc_hd__dfrtp_1
XFILLER_0_50_53 VPWR VGND VPWR VGND sky130_ef_sc_hd__decap_12
XANTENNA__4856__RESET_B net13 VGND VGND VPWR VPWR sky130_fd_sc_hd__diode_2
X_3634_ _1145_ VGND VGND VPWR VPWR _1146_ sky130_fd_sc_hd__clkbuf_1
XFILLER_0_50_97 VPWR VGND VPWR VGND sky130_ef_sc_hd__decap_12
XFILLER_0_70_165 VGND VGND VPWR VPWR sky130_fd_sc_hd__decap_4
XFILLER_0_43_379 VPWR VGND VPWR VGND sky130_ef_sc_hd__decap_12
X_3565_ _1098_ VGND VGND VPWR VPWR _1099_ sky130_fd_sc_hd__clkbuf_1
XFILLER_0_59_62 VGND VGND VPWR VPWR sky130_fd_sc_hd__fill_1
X_2516_ _1860_ VGND VGND VPWR VPWR _1861_ sky130_fd_sc_hd__clkbuf_1
X_3496_ tree_instances\[5\].u_tree.tree_state\[2\] tree_instances\[5\].u_tree.tree_state\[1\]
+ _0624_ VGND VGND VPWR VPWR _1053_ sky130_fd_sc_hd__or3_1
X_2447_ tree_instances\[10\].u_tree.pipeline_current_node\[0\]\[2\] VGND VGND VPWR
+ VPWR _1800_ sky130_fd_sc_hd__clkbuf_1
XFILLER_0_45_3 VPWR VGND VPWR VGND sky130_ef_sc_hd__decap_12
X_2378_ tree_instances\[14\].u_tree.pipeline_current_node\[0\]\[3\] _1738_ VGND VGND
+ VPWR VPWR _1739_ sky130_fd_sc_hd__or2_1
XFILLER_0_75_50 VGND VGND VPWR VPWR sky130_fd_sc_hd__decap_3
X_4117_ tree_instances\[18\].u_tree.pipeline_current_node\[0\]\[0\] VGND VGND VPWR
+ VPWR _1423_ sky130_fd_sc_hd__clkbuf_1
XTAP_TAPCELL_ROW_67_875 VGND VPWR sky130_fd_sc_hd__tapvpwrvgnd_1
X_4048_ tree_instances\[15\].u_tree.pipeline_frame_id\[0\]\[0\] _0664_ _0014_ VGND
+ VGND VPWR VPWR _1386_ sky130_fd_sc_hd__mux2_1
XTAP_TAPCELL_ROW_39_599 VGND VPWR sky130_fd_sc_hd__tapvpwrvgnd_1
XFILLER_0_91_93 VPWR VGND VPWR VGND sky130_ef_sc_hd__decap_12
XFILLER_0_93_246 VGND VGND VPWR VPWR sky130_fd_sc_hd__fill_1
XTAP_TAPCELL_ROW_22_433 VGND VPWR sky130_fd_sc_hd__tapvpwrvgnd_1
XFILLER_0_34_324 VGND VGND VPWR VPWR sky130_fd_sc_hd__fill_2
XFILLER_0_46_173 VPWR VGND VPWR VGND sky130_ef_sc_hd__decap_12
XANTENNA__4597__RESET_B net9 VGND VGND VPWR VPWR sky130_fd_sc_hd__diode_2
XANTENNA__4526__RESET_B net11 VGND VGND VPWR VPWR sky130_fd_sc_hd__diode_2
XFILLER_0_30_552 VPWR VGND VPWR VGND sky130_ef_sc_hd__decap_12
XFILLER_0_69_243 VPWR VGND VPWR VGND sky130_ef_sc_hd__decap_12
XFILLER_0_69_221 VGND VGND VPWR VPWR sky130_fd_sc_hd__decap_3
XFILLER_0_57_405 VPWR VGND VPWR VGND sky130_ef_sc_hd__decap_12
XFILLER_0_37_162 VGND VGND VPWR VPWR sky130_fd_sc_hd__fill_2
XFILLER_0_52_165 VGND VGND VPWR VPWR sky130_fd_sc_hd__decap_8
XFILLER_0_20_78 VGND VGND VPWR VPWR sky130_fd_sc_hd__decap_6
XFILLER_0_96_27 VGND VGND VPWR VPWR sky130_fd_sc_hd__fill_1
XTAP_TAPCELL_ROW_90_1104 VGND VPWR sky130_fd_sc_hd__tapvpwrvgnd_1
X_3350_ _0967_ VGND VGND VPWR VPWR _0170_ sky130_fd_sc_hd__clkbuf_1
X_2301_ tree_instances\[18\].u_tree.tree_state\[3\] VGND VGND VPWR VPWR _1670_ sky130_fd_sc_hd__buf_2
X_3281_ _0928_ VGND VGND VPWR VPWR _0140_ sky130_fd_sc_hd__clkbuf_1
XFILLER_0_29_76 VPWR VGND VPWR VGND sky130_ef_sc_hd__decap_12
X_2232_ _1608_ tree_instances\[11\].u_tree.pipeline_current_node\[0\]\[5\] VGND VGND
+ VPWR VPWR _1609_ sky130_fd_sc_hd__or2_1
Xclkbuf_leaf_2_clk clknet_3_0__leaf_clk VGND VGND VPWR VPWR clknet_leaf_2_clk sky130_fd_sc_hd__clkbuf_4
XTAP_TAPCELL_ROW_88_1088 VGND VPWR sky130_fd_sc_hd__tapvpwrvgnd_1
XTAP_TAPCELL_ROW_64_845 VGND VPWR sky130_fd_sc_hd__tapvpwrvgnd_1
XTAP_TAPCELL_ROW_36_569 VGND VPWR sky130_fd_sc_hd__tapvpwrvgnd_1
XFILLER_0_8_513 VPWR VGND VPWR VGND sky130_ef_sc_hd__decap_12
X_4804_ clknet_leaf_53_clk _0491_ net13 VGND VGND VPWR VPWR tree_instances\[17\].u_tree.pipeline_current_node\[0\]\[8\]
+ sky130_fd_sc_hd__dfrtp_1
X_4735_ clknet_leaf_35_clk _0433_ net10 VGND VGND VPWR VPWR tree_instances\[14\].u_tree.pipeline_frame_id\[0\]\[4\]
+ sky130_fd_sc_hd__dfrtp_1
X_2996_ tree_instances\[0\].u_tree.frame_id_in\[1\] VGND VGND VPWR VPWR _0672_ sky130_fd_sc_hd__buf_2
XFILLER_0_8_557 VPWR VGND VPWR VGND sky130_ef_sc_hd__decap_12
XFILLER_0_43_110 VGND VGND VPWR VPWR sky130_fd_sc_hd__fill_2
XFILLER_0_43_121 VGND VGND VPWR VPWR sky130_fd_sc_hd__decap_4
XANTENNA__4690__RESET_B net11 VGND VGND VPWR VPWR sky130_fd_sc_hd__diode_2
XFILLER_0_31_327 VGND VGND VPWR VPWR sky130_fd_sc_hd__decap_3
X_4666_ clknet_leaf_10_clk _0371_ tree_instances\[0\].u_tree.rst_n VGND VGND VPWR
+ VPWR tree_instances\[11\].u_tree.frame_id_out\[0\] sky130_fd_sc_hd__dfrtp_1
X_3617_ _1133_ VGND VGND VPWR VPWR _0271_ sky130_fd_sc_hd__clkbuf_1
X_4597_ clknet_leaf_63_clk _0032_ net9 VGND VGND VPWR VPWR tree_instances\[4\].u_tree.tree_state\[2\]
+ sky130_fd_sc_hd__dfrtp_1
XFILLER_0_12_530 VGND VGND VPWR VPWR sky130_fd_sc_hd__fill_2
X_3548_ _1087_ VGND VGND VPWR VPWR _0248_ sky130_fd_sc_hd__clkbuf_1
X_3479_ _1043_ VGND VGND VPWR VPWR _0223_ sky130_fd_sc_hd__clkbuf_1
XFILLER_0_79_552 VGND VGND VPWR VPWR sky130_fd_sc_hd__fill_1
XFILLER_0_94_533 VPWR VGND VPWR VGND sky130_ef_sc_hd__decap_12
XFILLER_0_66_213 VGND VGND VPWR VPWR sky130_fd_sc_hd__decap_3
XFILLER_0_39_438 VGND VGND VPWR VPWR sky130_fd_sc_hd__decap_3
XFILLER_0_39_449 VPWR VGND VPWR VGND sky130_ef_sc_hd__decap_12
XANTENNA__4778__RESET_B net13 VGND VGND VPWR VPWR sky130_fd_sc_hd__diode_2
XFILLER_0_34_132 VGND VGND VPWR VPWR sky130_fd_sc_hd__decap_8
XANTENNA__4707__RESET_B net9 VGND VGND VPWR VPWR sky130_fd_sc_hd__diode_2
XFILLER_0_22_305 VGND VGND VPWR VPWR sky130_fd_sc_hd__decap_3
XANTENNA__4360__RESET_B net12 VGND VGND VPWR VPWR sky130_fd_sc_hd__diode_2
XTAP_TAPCELL_ROW_7_283 VGND VPWR sky130_fd_sc_hd__tapvpwrvgnd_1
XFILLER_0_82_29 VPWR VGND VPWR VGND sky130_ef_sc_hd__decap_12
XFILLER_0_89_349 VPWR VGND VPWR VGND sky130_ef_sc_hd__decap_12
XFILLER_0_85_500 VGND VGND VPWR VPWR sky130_fd_sc_hd__decap_4
XFILLER_0_85_522 VGND VGND VPWR VPWR sky130_fd_sc_hd__fill_1
XTAP_TAPCELL_ROW_61_815 VGND VPWR sky130_fd_sc_hd__tapvpwrvgnd_1
XFILLER_0_15_89 VGND VGND VPWR VPWR sky130_fd_sc_hd__fill_2
X_2850_ tree_instances\[19\].u_tree.prediction_valid _1970_ VGND VGND VPWR VPWR _2153_
+ sky130_fd_sc_hd__and2b_1
XFILLER_0_57_279 VGND VGND VPWR VPWR sky130_fd_sc_hd__fill_1
XTAP_TAPCELL_ROW_33_539 VGND VPWR sky130_fd_sc_hd__tapvpwrvgnd_1
XFILLER_0_72_205 VGND VGND VPWR VPWR sky130_fd_sc_hd__fill_2
XFILLER_0_5_505 VPWR VGND VPWR VGND sky130_ef_sc_hd__decap_12
X_2781_ _2088_ VGND VGND VPWR VPWR _0090_ sky130_fd_sc_hd__clkbuf_1
XANTENNA__4448__RESET_B tree_instances\[0\].u_tree.rst_n VGND VGND VPWR VPWR sky130_fd_sc_hd__diode_2
XFILLER_0_25_143 VGND VGND VPWR VPWR sky130_fd_sc_hd__decap_8
XFILLER_0_80_271 VGND VGND VPWR VPWR sky130_fd_sc_hd__decap_6
XFILLER_0_13_305 VPWR VGND VPWR VGND sky130_ef_sc_hd__decap_12
X_4520_ clknet_leaf_59_clk _0101_ tree_instances\[0\].u_tree.rst_n VGND VGND VPWR
+ VPWR tree_instances\[5\].u_tree.prediction_valid sky130_fd_sc_hd__dfrtp_1
X_4451_ clknet_leaf_69_clk _0192_ tree_instances\[0\].u_tree.rst_n VGND VGND VPWR
+ VPWR tree_instances\[3\].u_tree.pipeline_current_node\[0\]\[3\] sky130_fd_sc_hd__dfrtp_1
XFILLER_0_0_221 VGND VGND VPWR VPWR sky130_fd_sc_hd__decap_3
X_3402_ _2122_ _0996_ VGND VGND VPWR VPWR _0999_ sky130_fd_sc_hd__and2_1
X_4382_ clknet_leaf_36_clk _0130_ net10 VGND VGND VPWR VPWR tree_instances\[0\].u_tree.pipeline_current_node\[0\]\[4\]
+ sky130_fd_sc_hd__dfrtp_1
XFILLER_0_40_179 VGND VGND VPWR VPWR sky130_fd_sc_hd__decap_8
X_3333_ _0955_ VGND VGND VPWR VPWR _0165_ sky130_fd_sc_hd__clkbuf_1
XFILLER_0_0_265 VPWR VGND VPWR VGND sky130_ef_sc_hd__decap_12
X_3264_ _0919_ VGND VGND VPWR VPWR _0132_ sky130_fd_sc_hd__clkbuf_1
XPHY_EDGE_ROW_7_Right_7 VGND VGND VPWR VPWR sky130_fd_sc_hd__decap_3
XFILLER_0_56_41 VPWR VGND VPWR VGND sky130_ef_sc_hd__decap_12
X_2215_ _1574_ tree_instances\[11\].u_tree.pipeline_valid\[0\] VGND VGND VPWR VPWR
+ _1594_ sky130_fd_sc_hd__or2_1
X_3195_ tree_instances\[13\].u_tree.frame_id_out\[0\] VGND VGND VPWR VPWR _0867_ sky130_fd_sc_hd__inv_2
XFILLER_0_56_85 VPWR VGND VPWR VGND sky130_ef_sc_hd__decap_12
XTAP_TAPCELL_ROW_77_981 VGND VPWR sky130_fd_sc_hd__tapvpwrvgnd_1
XTAP_TAPCELL_ROW_49_694 VGND VPWR sky130_fd_sc_hd__tapvpwrvgnd_1
XFILLER_0_72_62 VGND VGND VPWR VPWR sky130_fd_sc_hd__fill_2
XFILLER_0_76_544 VGND VGND VPWR VPWR sky130_fd_sc_hd__fill_1
XFILLER_0_76_533 VGND VGND VPWR VPWR sky130_fd_sc_hd__fill_1
XFILLER_0_48_213 VGND VGND VPWR VPWR sky130_fd_sc_hd__decap_6
XANTENNA__4871__RESET_B net10 VGND VGND VPWR VPWR sky130_fd_sc_hd__diode_2
XFILLER_0_63_249 VGND VGND VPWR VPWR sky130_fd_sc_hd__fill_2
XANTENNA__4800__RESET_B net13 VGND VGND VPWR VPWR sky130_fd_sc_hd__diode_2
XFILLER_0_44_430 VGND VGND VPWR VPWR sky130_fd_sc_hd__fill_2
X_2979_ _0657_ VGND VGND VPWR VPWR _0658_ sky130_fd_sc_hd__clkbuf_4
XFILLER_0_71_260 VGND VGND VPWR VPWR sky130_fd_sc_hd__decap_8
XANTENNA__3395__B1 _0012_ VGND VGND VPWR VPWR sky130_fd_sc_hd__diode_2
X_4718_ clknet_leaf_54_clk _0027_ tree_instances\[0\].u_tree.rst_n VGND VGND VPWR
+ VPWR tree_instances\[2\].u_tree.tree_state\[1\] sky130_fd_sc_hd__dfrtp_1
X_4649_ clknet_leaf_67_clk _0070_ net9 VGND VGND VPWR VPWR tree_instances\[3\].u_tree.tree_state\[3\]
+ sky130_fd_sc_hd__dfrtp_1
XFILLER_0_16_187 VGND VGND VPWR VPWR sky130_fd_sc_hd__decap_8
XTAP_TAPCELL_ROW_4_253 VGND VPWR sky130_fd_sc_hd__tapvpwrvgnd_1
XFILLER_0_79_393 VGND VGND VPWR VPWR sky130_fd_sc_hd__decap_6
XFILLER_0_39_213 VGND VGND VPWR VPWR sky130_fd_sc_hd__fill_2
XFILLER_0_94_352 VGND VGND VPWR VPWR sky130_fd_sc_hd__decap_4
XFILLER_0_94_385 VGND VGND VPWR VPWR sky130_fd_sc_hd__decap_3
XTAP_TAPCELL_ROW_30_509 VGND VPWR sky130_fd_sc_hd__tapvpwrvgnd_1
XFILLER_0_54_227 VGND VGND VPWR VPWR sky130_fd_sc_hd__fill_1
XANTENNA__4541__RESET_B net11 VGND VGND VPWR VPWR sky130_fd_sc_hd__diode_2
XFILLER_0_35_441 VGND VGND VPWR VPWR sky130_fd_sc_hd__fill_1
XFILLER_0_22_168 VGND VGND VPWR VPWR sky130_fd_sc_hd__decap_8
XFILLER_0_50_466 VGND VGND VPWR VPWR sky130_fd_sc_hd__decap_8
XFILLER_0_50_477 VPWR VGND VPWR VGND sky130_ef_sc_hd__decap_12
XFILLER_0_89_113 VGND VGND VPWR VPWR sky130_fd_sc_hd__fill_1
XANTENNA__3043__A _0714_ VGND VGND VPWR VPWR sky130_fd_sc_hd__diode_2
XTAP_TAPCELL_ROW_74_951 VGND VPWR sky130_fd_sc_hd__tapvpwrvgnd_1
XFILLER_0_58_500 VGND VGND VPWR VPWR sky130_fd_sc_hd__fill_2
XTAP_TAPCELL_ROW_85_1058 VGND VPWR sky130_fd_sc_hd__tapvpwrvgnd_1
XFILLER_0_58_533 VPWR VGND VPWR VGND sky130_ef_sc_hd__decap_12
X_3951_ _1336_ VGND VGND VPWR VPWR _0402_ sky130_fd_sc_hd__clkbuf_1
XANTENNA__4629__RESET_B net9 VGND VGND VPWR VPWR sky130_fd_sc_hd__diode_2
XTAP_TAPCELL_ROW_46_664 VGND VPWR sky130_fd_sc_hd__tapvpwrvgnd_1
XFILLER_0_85_341 VPWR VGND VPWR VGND sky130_ef_sc_hd__decap_12
X_2902_ _0605_ _1578_ VGND VGND VPWR VPWR _0606_ sky130_fd_sc_hd__or2_1
XTAP_TAPCELL_ROW_18_388 VGND VPWR sky130_fd_sc_hd__tapvpwrvgnd_1
X_3882_ _1288_ VGND VGND VPWR VPWR _1292_ sky130_fd_sc_hd__clkbuf_1
X_2833_ _1630_ VGND VGND VPWR VPWR _2136_ sky130_fd_sc_hd__clkbuf_1
XFILLER_0_45_238 VGND VGND VPWR VPWR sky130_fd_sc_hd__fill_2
X_2764_ tree_instances\[8\].u_tree.pipeline_current_node\[0\]\[5\] VGND VGND VPWR
+ VPWR _2072_ sky130_fd_sc_hd__clkbuf_1
XFILLER_0_5_335 VGND VGND VPWR VPWR sky130_fd_sc_hd__fill_1
XFILLER_0_13_113 VPWR VGND VPWR VGND sky130_ef_sc_hd__decap_12
XFILLER_0_13_102 VGND VGND VPWR VPWR sky130_fd_sc_hd__decap_3
X_4503_ clknet_leaf_53_clk _0234_ net13 VGND VGND VPWR VPWR tree_instances\[5\].u_tree.pipeline_current_node\[0\]\[3\]
+ sky130_fd_sc_hd__dfrtp_1
XFILLER_0_26_485 VGND VGND VPWR VPWR sky130_fd_sc_hd__fill_1
XFILLER_0_41_411 VGND VGND VPWR VPWR sky130_fd_sc_hd__decap_8
XTAP_TAPCELL_ROW_96_1176 VGND VPWR sky130_fd_sc_hd__tapvpwrvgnd_1
XTAP_TAPCELL_ROW_96_1165 VGND VPWR sky130_fd_sc_hd__tapvpwrvgnd_1
X_2695_ _2012_ VGND VGND VPWR VPWR _2014_ sky130_fd_sc_hd__clkbuf_1
XFILLER_0_1_541 VPWR VGND VPWR VGND sky130_ef_sc_hd__decap_12
X_4434_ clknet_leaf_58_clk _0180_ net13 VGND VGND VPWR VPWR tree_instances\[2\].u_tree.pipeline_frame_id\[0\]\[3\]
+ sky130_fd_sc_hd__dfrtp_1
XFILLER_0_41_499 VGND VGND VPWR VPWR sky130_fd_sc_hd__decap_4
XFILLER_0_6_65 VGND VGND VPWR VPWR sky130_fd_sc_hd__fill_1
X_4365_ clknet_leaf_7_clk _0125_ net12 VGND VGND VPWR VPWR current_voting_frame\[4\]
+ sky130_fd_sc_hd__dfrtp_1
X_3316_ tree_instances\[1\].u_tree.pipeline_frame_id\[0\]\[1\] _0673_ _0024_ VGND
+ VGND VPWR VPWR _0947_ sky130_fd_sc_hd__mux2_1
X_4296_ _2139_ _1524_ VGND VGND VPWR VPWR _1531_ sky130_fd_sc_hd__and2_1
XANTENNA_clkbuf_leaf_21_clk_A clknet_3_3__leaf_clk VGND VGND VPWR VPWR sky130_fd_sc_hd__diode_2
X_3247_ _0910_ VGND VGND VPWR VPWR _0124_ sky130_fd_sc_hd__clkbuf_1
XTAP_TAPCELL_ROW_1_223 VGND VPWR sky130_fd_sc_hd__tapvpwrvgnd_1
XANTENNA__3852__A1 _1168_ VGND VGND VPWR VPWR sky130_fd_sc_hd__diode_2
X_3178_ tree_instances\[20\].u_tree.frame_id_out\[4\] _0660_ VGND VGND VPWR VPWR _0850_
+ sky130_fd_sc_hd__or2b_1
XANTENNA_clkbuf_leaf_36_clk_A clknet_3_7__leaf_clk VGND VGND VPWR VPWR sky130_fd_sc_hd__diode_2
XANTENNA__3604__A1 _0925_ VGND VGND VPWR VPWR sky130_fd_sc_hd__diode_2
XFILLER_0_76_352 VPWR VGND VPWR VGND sky130_ef_sc_hd__decap_12
XFILLER_0_36_249 VGND VGND VPWR VPWR sky130_fd_sc_hd__decap_3
XFILLER_0_91_388 VGND VGND VPWR VPWR sky130_fd_sc_hd__decap_4
XFILLER_0_17_485 VPWR VGND VPWR VGND sky130_ef_sc_hd__decap_12
XTAP_TAPCELL_ROW_9_301 VGND VPWR sky130_fd_sc_hd__tapvpwrvgnd_1
XFILLER_0_32_477 VGND VGND VPWR VPWR sky130_fd_sc_hd__fill_2
XFILLER_0_12_190 VGND VGND VPWR VPWR sky130_fd_sc_hd__decap_6
XANTENNA__2967__A _0648_ VGND VGND VPWR VPWR sky130_fd_sc_hd__diode_2
XANTENNA__4096__A1 _0674_ VGND VGND VPWR VPWR sky130_fd_sc_hd__diode_2
XFILLER_0_86_138 VGND VGND VPWR VPWR sky130_fd_sc_hd__fill_2
XANTENNA__4722__RESET_B net10 VGND VGND VPWR VPWR sky130_fd_sc_hd__diode_2
XTAP_TAPCELL_ROW_71_921 VGND VPWR sky130_fd_sc_hd__tapvpwrvgnd_1
XFILLER_0_67_330 VGND VGND VPWR VPWR sky130_fd_sc_hd__fill_2
XTAP_TAPCELL_ROW_43_634 VGND VPWR sky130_fd_sc_hd__tapvpwrvgnd_1
XTAP_TAPCELL_ROW_15_358 VGND VPWR sky130_fd_sc_hd__tapvpwrvgnd_1
XFILLER_0_82_344 VPWR VGND VPWR VGND sky130_ef_sc_hd__decap_12
XFILLER_0_27_238 VGND VGND VPWR VPWR sky130_fd_sc_hd__decap_8
XFILLER_0_12_68 VPWR VGND VPWR VGND sky130_ef_sc_hd__decap_12
XFILLER_0_2_305 VGND VGND VPWR VPWR sky130_fd_sc_hd__decap_3
XFILLER_0_35_293 VPWR VGND VPWR VGND sky130_ef_sc_hd__decap_12
X_2480_ tree_instances\[17\].u_tree.tree_state\[0\] _1828_ VGND VGND VPWR VPWR _1829_
+ sky130_fd_sc_hd__and2_1
XFILLER_0_50_285 VGND VGND VPWR VPWR sky130_fd_sc_hd__decap_3
XANTENNA__4323__A2 net8 VGND VGND VPWR VPWR sky130_fd_sc_hd__diode_2
XFILLER_0_10_138 VGND VGND VPWR VPWR sky130_fd_sc_hd__fill_2
X_4150_ _1451_ VGND VGND VPWR VPWR _1452_ sky130_fd_sc_hd__clkbuf_1
X_3101_ tree_instances\[0\].u_tree.frame_id_out\[4\] VGND VGND VPWR VPWR _0773_ sky130_fd_sc_hd__inv_2
X_4081_ _1403_ VGND VGND VPWR VPWR _0465_ sky130_fd_sc_hd__clkbuf_1
X_3032_ _0703_ VGND VGND VPWR VPWR _0704_ sky130_fd_sc_hd__buf_2
XFILLER_0_58_352 VGND VGND VPWR VPWR sky130_fd_sc_hd__fill_2
XANTENNA__4463__RESET_B net9 VGND VGND VPWR VPWR sky130_fd_sc_hd__diode_2
X_3934_ _1318_ VGND VGND VPWR VPWR _1324_ sky130_fd_sc_hd__clkbuf_1
XFILLER_0_85_193 VGND VGND VPWR VPWR sky130_fd_sc_hd__decap_8
X_3865_ tree_instances\[6\].u_tree.pipeline_valid\[0\] tree_instances\[6\].u_tree.tree_state\[0\]
+ VGND VGND VPWR VPWR _1276_ sky130_fd_sc_hd__nand2_1
XFILLER_0_61_517 VGND VGND VPWR VPWR sky130_fd_sc_hd__decap_3
X_2816_ tree_instances\[3\].u_tree.pipeline_current_node\[0\]\[6\] VGND VGND VPWR
+ VPWR _2120_ sky130_fd_sc_hd__clkbuf_1
XANTENNA__4011__A1 _1192_ VGND VGND VPWR VPWR sky130_fd_sc_hd__diode_2
XFILLER_0_5_143 VPWR VGND VPWR VGND sky130_ef_sc_hd__decap_12
X_3796_ _0596_ _1231_ VGND VGND VPWR VPWR _1241_ sky130_fd_sc_hd__and2_1
XFILLER_0_14_433 VGND VGND VPWR VPWR sky130_fd_sc_hd__decap_4
X_2747_ _2057_ VGND VGND VPWR VPWR _2058_ sky130_fd_sc_hd__clkbuf_1
XFILLER_0_75_3 VGND VGND VPWR VPWR sky130_fd_sc_hd__decap_8
XFILLER_0_14_477 VPWR VGND VPWR VGND sky130_ef_sc_hd__decap_12
X_2678_ _1723_ VGND VGND VPWR VPWR _1999_ sky130_fd_sc_hd__clkbuf_1
XFILLER_0_78_83 VGND VGND VPWR VPWR sky130_fd_sc_hd__fill_1
X_4417_ clknet_leaf_22_clk _0164_ net11 VGND VGND VPWR VPWR tree_instances\[1\].u_tree.frame_id_out\[3\]
+ sky130_fd_sc_hd__dfrtp_1
XFILLER_0_1_360 VGND VGND VPWR VPWR sky130_fd_sc_hd__fill_2
XFILLER_0_1_382 VGND VGND VPWR VPWR sky130_fd_sc_hd__decap_4
XFILLER_0_1_393 VGND VGND VPWR VPWR sky130_fd_sc_hd__fill_2
X_4348_ clknet_leaf_13_clk _0108_ net12 VGND VGND VPWR VPWR net4 sky130_fd_sc_hd__dfrtp_1
X_4279_ _1970_ _1500_ _0640_ tree_instances\[19\].u_tree.ready_for_next VGND VGND
+ VPWR VPWR _0545_ sky130_fd_sc_hd__a22o_1
XFILLER_0_68_105 VGND VGND VPWR VPWR sky130_fd_sc_hd__fill_2
XFILLER_0_49_341 VGND VGND VPWR VPWR sky130_fd_sc_hd__fill_1
XFILLER_0_37_503 VGND VGND VPWR VPWR sky130_fd_sc_hd__fill_1
XFILLER_0_49_374 VGND VGND VPWR VPWR sky130_fd_sc_hd__fill_2
XFILLER_0_9_460 VGND VGND VPWR VPWR sky130_fd_sc_hd__decap_3
XFILLER_0_37_547 VGND VGND VPWR VPWR sky130_fd_sc_hd__decap_3
XFILLER_0_37_558 VGND VGND VPWR VPWR sky130_fd_sc_hd__fill_2
XTAP_TAPCELL_ROW_40_604 VGND VPWR sky130_fd_sc_hd__tapvpwrvgnd_1
XFILLER_0_64_377 VPWR VGND VPWR VGND sky130_ef_sc_hd__decap_12
XTAP_TAPCELL_ROW_12_328 VGND VPWR sky130_fd_sc_hd__tapvpwrvgnd_1
XFILLER_0_20_469 VGND VGND VPWR VPWR sky130_fd_sc_hd__fill_1
XFILLER_0_90_29 VPWR VGND VPWR VGND sky130_ef_sc_hd__decap_12
XFILLER_0_87_447 VGND VGND VPWR VPWR sky130_fd_sc_hd__fill_1
XTAP_TAPCELL_ROW_82_1028 VGND VPWR sky130_fd_sc_hd__tapvpwrvgnd_1
XFILLER_0_59_138 VGND VGND VPWR VPWR sky130_fd_sc_hd__fill_2
XTAP_TAPCELL_ROW_56_770 VGND VPWR sky130_fd_sc_hd__tapvpwrvgnd_1
XFILLER_0_23_78 VGND VGND VPWR VPWR sky130_fd_sc_hd__decap_6
XFILLER_0_82_130 VGND VGND VPWR VPWR sky130_fd_sc_hd__decap_6
X_3650_ _1157_ VGND VGND VPWR VPWR _1158_ sky130_fd_sc_hd__clkbuf_1
XFILLER_0_55_388 VGND VGND VPWR VPWR sky130_fd_sc_hd__fill_1
X_3581_ _1111_ VGND VGND VPWR VPWR _1112_ sky130_fd_sc_hd__clkbuf_1
X_2601_ tree_instances\[1\].u_tree.tree_state\[3\] VGND VGND VPWR VPWR _1932_ sky130_fd_sc_hd__inv_2
X_2532_ _1873_ VGND VGND VPWR VPWR _0037_ sky130_fd_sc_hd__clkbuf_1
XFILLER_0_51_561 VPWR VGND VPWR VGND sky130_ef_sc_hd__decap_12
XTAP_TAPCELL_ROW_93_1135 VGND VPWR sky130_fd_sc_hd__tapvpwrvgnd_1
XFILLER_0_23_285 VGND VGND VPWR VPWR sky130_fd_sc_hd__fill_1
XFILLER_0_11_469 VGND VGND VPWR VPWR sky130_fd_sc_hd__fill_2
X_2463_ _1813_ VGND VGND VPWR VPWR _1814_ sky130_fd_sc_hd__clkbuf_1
X_4202_ _1482_ VGND VGND VPWR VPWR _0507_ sky130_fd_sc_hd__clkbuf_1
X_2394_ _1750_ _1752_ VGND VGND VPWR VPWR _1753_ sky130_fd_sc_hd__or2_1
X_4133_ _2140_ VGND VGND VPWR VPWR _1438_ sky130_fd_sc_hd__clkbuf_1
XFILLER_0_3_33 VPWR VGND VPWR VGND sky130_ef_sc_hd__decap_12
X_4064_ tree_instances\[15\].u_tree.frame_id_out\[3\] tree_instances\[15\].u_tree.pipeline_frame_id\[0\]\[3\]
+ _1936_ VGND VGND VPWR VPWR _1394_ sky130_fd_sc_hd__mux2_1
X_3015_ _0648_ tree_instances\[6\].u_tree.frame_id_out\[0\] tree_instances\[6\].u_tree.frame_id_out\[1\]
+ _0686_ VGND VGND VPWR VPWR _0687_ sky130_fd_sc_hd__o22ai_1
XFILLER_0_64_85 VGND VGND VPWR VPWR sky130_fd_sc_hd__fill_1
XFILLER_0_93_439 VGND VGND VPWR VPWR sky130_fd_sc_hd__fill_2
XFILLER_0_19_503 VGND VGND VPWR VPWR sky130_fd_sc_hd__fill_1
XFILLER_0_46_322 VGND VGND VPWR VPWR sky130_fd_sc_hd__fill_2
X_3917_ tree_instances\[12\].u_tree.frame_id_out\[2\] tree_instances\[12\].u_tree.pipeline_frame_id\[0\]\[2\]
+ _1579_ VGND VGND VPWR VPWR _1311_ sky130_fd_sc_hd__mux2_1
X_4897_ clknet_leaf_25_clk _0568_ net11 VGND VGND VPWR VPWR state\[1\] sky130_fd_sc_hd__dfrtp_1
XFILLER_0_46_377 VGND VGND VPWR VPWR sky130_fd_sc_hd__decap_4
XFILLER_0_61_325 VGND VGND VPWR VPWR sky130_fd_sc_hd__fill_1
X_3848_ tree_instances\[11\].u_tree.pipeline_frame_id\[0\]\[2\] _1165_ _0006_ VGND
+ VGND VPWR VPWR _1268_ sky130_fd_sc_hd__mux2_1
XFILLER_0_34_528 VGND VGND VPWR VPWR sky130_fd_sc_hd__decap_4
XFILLER_0_61_347 VGND VGND VPWR VPWR sky130_fd_sc_hd__fill_2
X_3779_ _1231_ VGND VGND VPWR VPWR _1232_ sky130_fd_sc_hd__buf_1
XFILLER_0_14_285 VGND VGND VPWR VPWR sky130_fd_sc_hd__fill_1
XFILLER_0_10_480 VGND VGND VPWR VPWR sky130_fd_sc_hd__fill_1
XANTENNA__4385__RESET_B net10 VGND VGND VPWR VPWR sky130_fd_sc_hd__diode_2
XANTENNA__3141__A _0661_ VGND VGND VPWR VPWR sky130_fd_sc_hd__diode_2
XFILLER_0_96_277 VGND VGND VPWR VPWR sky130_fd_sc_hd__decap_3
XFILLER_0_49_160 VGND VGND VPWR VPWR sky130_fd_sc_hd__fill_2
XTAP_TAPCELL_ROW_53_740 VGND VPWR sky130_fd_sc_hd__tapvpwrvgnd_1
XFILLER_0_37_333 VGND VGND VPWR VPWR sky130_fd_sc_hd__decap_3
XFILLER_0_92_483 VGND VGND VPWR VPWR sky130_fd_sc_hd__fill_1
XFILLER_0_25_528 VGND VGND VPWR VPWR sky130_fd_sc_hd__decap_4
XFILLER_0_52_325 VPWR VGND VPWR VGND sky130_ef_sc_hd__decap_12
XFILLER_0_52_369 VGND VGND VPWR VPWR sky130_fd_sc_hd__fill_1
XFILLER_0_87_222 VGND VGND VPWR VPWR sky130_fd_sc_hd__fill_2
X_4820_ clknet_leaf_31_clk _0064_ net11 VGND VGND VPWR VPWR tree_instances\[1\].u_tree.tree_state\[3\]
+ sky130_fd_sc_hd__dfrtp_4
XFILLER_0_75_406 VGND VGND VPWR VPWR sky130_fd_sc_hd__fill_1
XFILLER_0_47_108 VGND VGND VPWR VPWR sky130_fd_sc_hd__fill_2
XFILLER_0_83_461 VPWR VGND VPWR VGND sky130_ef_sc_hd__decap_12
X_4751_ clknet_leaf_41_clk _0448_ net10 VGND VGND VPWR VPWR tree_instances\[15\].u_tree.pipeline_current_node\[0\]\[7\]
+ sky130_fd_sc_hd__dfrtp_1
X_4682_ clknet_leaf_17_clk _0386_ net11 VGND VGND VPWR VPWR tree_instances\[12\].u_tree.pipeline_current_node\[0\]\[8\]
+ sky130_fd_sc_hd__dfrtp_1
X_3702_ _2080_ _1178_ VGND VGND VPWR VPWR _1188_ sky130_fd_sc_hd__and2_1
XFILLER_0_7_249 VPWR VGND VPWR VGND sky130_ef_sc_hd__decap_12
XFILLER_0_16_517 VPWR VGND VPWR VGND sky130_ef_sc_hd__decap_12
XFILLER_0_50_65 VPWR VGND VPWR VGND sky130_ef_sc_hd__decap_12
XFILLER_0_70_133 VGND VGND VPWR VPWR sky130_fd_sc_hd__fill_2
X_3633_ _1144_ VGND VGND VPWR VPWR _1145_ sky130_fd_sc_hd__clkbuf_1
XFILLER_0_31_509 VGND VGND VPWR VPWR sky130_fd_sc_hd__decap_4
X_3564_ tree_instances\[6\].u_tree.pipeline_current_node\[0\]\[1\] VGND VGND VPWR
+ VPWR _1098_ sky130_fd_sc_hd__clkbuf_1
XFILLER_0_59_30 VGND VGND VPWR VPWR sky130_fd_sc_hd__fill_2
XANTENNA__4896__RESET_B net11 VGND VGND VPWR VPWR sky130_fd_sc_hd__diode_2
X_2515_ _1859_ tree_instances\[13\].u_tree.pipeline_current_node\[0\]\[6\] VGND VGND
+ VPWR VPWR _1860_ sky130_fd_sc_hd__nor2_1
X_3495_ _1051_ VGND VGND VPWR VPWR _1052_ sky130_fd_sc_hd__clkbuf_1
X_2446_ tree_instances\[10\].u_tree.pipeline_current_node\[0\]\[0\] tree_instances\[10\].u_tree.pipeline_current_node\[0\]\[1\]
+ VGND VGND VPWR VPWR _1799_ sky130_fd_sc_hd__or2_1
XANTENNA__4825__RESET_B net10 VGND VGND VPWR VPWR sky130_fd_sc_hd__diode_2
X_2377_ tree_instances\[14\].u_tree.pipeline_current_node\[0\]\[2\] VGND VGND VPWR
+ VPWR _1738_ sky130_fd_sc_hd__clkbuf_1
XPHY_EDGE_ROW_3_Left_100 VGND VGND VPWR VPWR sky130_fd_sc_hd__decap_3
XFILLER_0_38_3 VPWR VGND VPWR VGND sky130_ef_sc_hd__decap_12
X_4116_ _1962_ VGND VGND VPWR VPWR _1422_ sky130_fd_sc_hd__clkbuf_1
XANTENNA__4489__SET_B tree_instances\[0\].u_tree.rst_n VGND VGND VPWR VPWR sky130_fd_sc_hd__diode_2
XTAP_TAPCELL_ROW_67_876 VGND VPWR sky130_fd_sc_hd__tapvpwrvgnd_1
X_4047_ _1385_ VGND VGND VPWR VPWR _0449_ sky130_fd_sc_hd__clkbuf_1
XFILLER_0_78_222 VPWR VGND VPWR VGND sky130_ef_sc_hd__decap_12
XFILLER_0_78_288 VGND VGND VPWR VPWR sky130_fd_sc_hd__fill_2
XFILLER_0_93_225 VGND VGND VPWR VPWR sky130_fd_sc_hd__fill_1
XFILLER_0_46_141 VGND VGND VPWR VPWR sky130_fd_sc_hd__decap_6
XTAP_TAPCELL_ROW_50_710 VGND VPWR sky130_fd_sc_hd__tapvpwrvgnd_1
XFILLER_0_19_388 VGND VGND VPWR VPWR sky130_fd_sc_hd__decap_4
XFILLER_0_46_185 VGND VGND VPWR VPWR sky130_fd_sc_hd__decap_8
XPHY_EDGE_ROW_49_Left_146 VGND VGND VPWR VPWR sky130_fd_sc_hd__decap_3
XFILLER_0_61_133 VPWR VGND VPWR VGND sky130_ef_sc_hd__decap_12
XFILLER_0_6_271 VPWR VGND VPWR VGND sky130_ef_sc_hd__decap_12
XFILLER_0_61_155 VGND VGND VPWR VPWR sky130_fd_sc_hd__decap_8
XFILLER_0_15_561 VPWR VGND VPWR VGND sky130_ef_sc_hd__decap_12
XFILLER_0_30_531 VGND VGND VPWR VPWR sky130_fd_sc_hd__fill_1
XFILLER_0_30_564 VGND VGND VPWR VPWR sky130_fd_sc_hd__decap_8
XANTENNA__3192__A1 _0696_ VGND VGND VPWR VPWR sky130_fd_sc_hd__diode_2
XANTENNA__4566__RESET_B net9 VGND VGND VPWR VPWR sky130_fd_sc_hd__diode_2
XPHY_EDGE_ROW_58_Left_155 VGND VGND VPWR VPWR sky130_fd_sc_hd__decap_3
XANTENNA__2975__A _0654_ VGND VGND VPWR VPWR sky130_fd_sc_hd__diode_2
XFILLER_0_69_255 VPWR VGND VPWR VGND sky130_ef_sc_hd__decap_12
XFILLER_0_57_417 VPWR VGND VPWR VGND sky130_ef_sc_hd__decap_12
XPHY_EDGE_ROW_67_Left_164 VGND VGND VPWR VPWR sky130_fd_sc_hd__decap_3
XFILLER_0_65_461 VGND VGND VPWR VPWR sky130_fd_sc_hd__decap_4
XANTENNA__2215__A _1574_ VGND VGND VPWR VPWR sky130_fd_sc_hd__diode_2
XFILLER_0_4_208 VGND VGND VPWR VPWR sky130_fd_sc_hd__fill_2
XFILLER_0_52_122 VGND VGND VPWR VPWR sky130_fd_sc_hd__fill_2
XFILLER_0_40_306 VGND VGND VPWR VPWR sky130_fd_sc_hd__fill_2
XFILLER_0_33_391 VGND VGND VPWR VPWR sky130_fd_sc_hd__fill_1
XTAP_TAPCELL_ROW_90_1105 VGND VPWR sky130_fd_sc_hd__tapvpwrvgnd_1
XANTENNA__3183__A1 _0662_ VGND VGND VPWR VPWR sky130_fd_sc_hd__diode_2
X_3280_ tree_instances\[0\].u_tree.frame_id_out\[0\] tree_instances\[0\].u_tree.pipeline_frame_id\[0\]\[0\]
+ _1832_ VGND VGND VPWR VPWR _0928_ sky130_fd_sc_hd__mux2_1
XPHY_EDGE_ROW_76_Left_173 VGND VGND VPWR VPWR sky130_fd_sc_hd__decap_3
X_2300_ _1666_ tree_instances\[18\].u_tree.pipeline_valid\[0\] VGND VGND VPWR VPWR
+ _1669_ sky130_fd_sc_hd__or2_1
XANTENNA__4132__B1 _0026_ VGND VGND VPWR VPWR sky130_fd_sc_hd__diode_2
X_2231_ tree_instances\[11\].u_tree.pipeline_current_node\[0\]\[4\] VGND VGND VPWR
+ VPWR _1608_ sky130_fd_sc_hd__clkbuf_1
XFILLER_0_29_88 VGND VGND VPWR VPWR sky130_fd_sc_hd__decap_3
XTAP_TAPCELL_ROW_88_1089 VGND VPWR sky130_fd_sc_hd__tapvpwrvgnd_1
XTAP_TAPCELL_ROW_64_846 VGND VPWR sky130_fd_sc_hd__tapvpwrvgnd_1
XPHY_EDGE_ROW_85_Left_182 VGND VGND VPWR VPWR sky130_fd_sc_hd__decap_3
XFILLER_0_75_225 VPWR VGND VPWR VGND sky130_ef_sc_hd__decap_12
XFILLER_0_61_31 VGND VGND VPWR VPWR sky130_fd_sc_hd__fill_2
XFILLER_0_8_525 VGND VGND VPWR VPWR sky130_fd_sc_hd__decap_6
X_4803_ clknet_leaf_53_clk _0490_ net13 VGND VGND VPWR VPWR tree_instances\[17\].u_tree.pipeline_current_node\[0\]\[7\]
+ sky130_fd_sc_hd__dfrtp_1
XFILLER_0_28_141 VPWR VGND VPWR VGND sky130_ef_sc_hd__decap_12
X_4734_ clknet_leaf_25_clk _0432_ net11 VGND VGND VPWR VPWR tree_instances\[14\].u_tree.pipeline_frame_id\[0\]\[3\]
+ sky130_fd_sc_hd__dfrtp_1
X_2995_ _0670_ _0671_ VGND VGND VPWR VPWR _0111_ sky130_fd_sc_hd__nor2_1
XFILLER_0_8_569 VGND VGND VPWR VPWR sky130_fd_sc_hd__decap_4
XFILLER_0_16_336 VGND VGND VPWR VPWR sky130_fd_sc_hd__fill_2
X_4665_ clknet_leaf_12_clk _0370_ tree_instances\[0\].u_tree.rst_n VGND VGND VPWR
+ VPWR tree_instances\[11\].u_tree.pipeline_frame_id\[0\]\[4\] sky130_fd_sc_hd__dfrtp_1
X_3616_ tree_instances\[6\].u_tree.frame_id_out\[4\] tree_instances\[6\].u_tree.pipeline_frame_id\[0\]\[4\]
+ tree_instances\[6\].u_tree.tree_state\[3\] VGND VGND VPWR VPWR _1133_ sky130_fd_sc_hd__mux2_1
X_4596_ clknet_leaf_64_clk _0031_ net9 VGND VGND VPWR VPWR tree_instances\[4\].u_tree.tree_state\[1\]
+ sky130_fd_sc_hd__dfrtp_1
XPHY_EDGE_ROW_94_Left_191 VGND VGND VPWR VPWR sky130_fd_sc_hd__decap_3
X_3547_ tree_instances\[5\].u_tree.frame_id_out\[3\] tree_instances\[5\].u_tree.pipeline_frame_id\[0\]\[3\]
+ _1770_ VGND VGND VPWR VPWR _1087_ sky130_fd_sc_hd__mux2_1
X_3478_ tree_instances\[4\].u_tree.pipeline_frame_id\[0\]\[4\] _0682_ _0032_ VGND
+ VGND VPWR VPWR _1043_ sky130_fd_sc_hd__mux2_1
X_2429_ tree_instances\[16\].u_tree.pipeline_current_node\[0\]\[5\] VGND VGND VPWR
+ VPWR _1783_ sky130_fd_sc_hd__clkbuf_1
XFILLER_0_94_501 VGND VGND VPWR VPWR sky130_fd_sc_hd__fill_2
XFILLER_0_79_564 VGND VGND VPWR VPWR sky130_fd_sc_hd__decap_8
XFILLER_0_94_545 VPWR VGND VPWR VGND sky130_ef_sc_hd__decap_12
XFILLER_0_66_258 VGND VGND VPWR VPWR sky130_fd_sc_hd__decap_6
XANTENNA__4747__RESET_B net10 VGND VGND VPWR VPWR sky130_fd_sc_hd__diode_2
XFILLER_0_15_391 VGND VGND VPWR VPWR sky130_fd_sc_hd__fill_1
XANTENNA__3165__B2 _0696_ VGND VGND VPWR VPWR sky130_fd_sc_hd__diode_2
XANTENNA__3165__A1 _0702_ VGND VGND VPWR VPWR sky130_fd_sc_hd__diode_2
XFILLER_0_30_372 VGND VGND VPWR VPWR sky130_fd_sc_hd__decap_4
XFILLER_0_15_35 VGND VGND VPWR VPWR sky130_fd_sc_hd__decap_4
XFILLER_0_15_57 VPWR VGND VPWR VGND sky130_ef_sc_hd__decap_12
XTAP_TAPCELL_ROW_61_816 VGND VPWR sky130_fd_sc_hd__tapvpwrvgnd_1
XFILLER_0_57_225 VPWR VGND VPWR VGND sky130_ef_sc_hd__decap_12
XFILLER_0_72_228 VGND VGND VPWR VPWR sky130_fd_sc_hd__fill_2
XFILLER_0_38_461 VGND VGND VPWR VPWR sky130_fd_sc_hd__decap_3
X_2780_ tree_instances\[14\].u_tree.prediction_valid _1889_ VGND VGND VPWR VPWR _2088_
+ sky130_fd_sc_hd__and2b_1
XFILLER_0_5_517 VPWR VGND VPWR VGND sky130_ef_sc_hd__decap_12
XFILLER_0_13_317 VPWR VGND VPWR VGND sky130_ef_sc_hd__decap_12
X_4450_ clknet_leaf_70_clk _0191_ tree_instances\[0\].u_tree.rst_n VGND VGND VPWR
+ VPWR tree_instances\[3\].u_tree.pipeline_current_node\[0\]\[2\] sky130_fd_sc_hd__dfrtp_1
XANTENNA__4488__RESET_B net9 VGND VGND VPWR VPWR sky130_fd_sc_hd__diode_2
X_4381_ clknet_leaf_37_clk _0129_ net10 VGND VGND VPWR VPWR tree_instances\[0\].u_tree.pipeline_current_node\[0\]\[3\]
+ sky130_fd_sc_hd__dfrtp_1
XANTENNA__4417__RESET_B net11 VGND VGND VPWR VPWR sky130_fd_sc_hd__diode_2
X_3401_ _0998_ VGND VGND VPWR VPWR _0190_ sky130_fd_sc_hd__clkbuf_1
XFILLER_0_40_147 VGND VGND VPWR VPWR sky130_fd_sc_hd__fill_1
X_3332_ tree_instances\[1\].u_tree.frame_id_out\[4\] tree_instances\[1\].u_tree.pipeline_frame_id\[0\]\[4\]
+ tree_instances\[1\].u_tree.tree_state\[3\] VGND VGND VPWR VPWR _0955_ sky130_fd_sc_hd__mux2_1
XFILLER_0_0_277 VGND VGND VPWR VPWR sky130_fd_sc_hd__decap_3
X_3263_ _2134_ _0912_ VGND VGND VPWR VPWR _0919_ sky130_fd_sc_hd__and2_1
X_2214_ _1593_ VGND VGND VPWR VPWR _0041_ sky130_fd_sc_hd__clkbuf_1
X_3194_ _0646_ tree_instances\[13\].u_tree.frame_id_out\[0\] tree_instances\[13\].u_tree.frame_id_out\[4\]
+ _0695_ _0865_ VGND VGND VPWR VPWR _0866_ sky130_fd_sc_hd__o221a_1
XFILLER_0_56_53 VPWR VGND VPWR VGND sky130_ef_sc_hd__decap_12
XFILLER_0_56_97 VGND VGND VPWR VPWR sky130_fd_sc_hd__decap_4
XTAP_TAPCELL_ROW_77_982 VGND VPWR sky130_fd_sc_hd__tapvpwrvgnd_1
XFILLER_0_72_41 VGND VGND VPWR VPWR sky130_fd_sc_hd__fill_1
XTAP_TAPCELL_ROW_49_695 VGND VPWR sky130_fd_sc_hd__tapvpwrvgnd_1
XFILLER_0_72_85 VGND VGND VPWR VPWR sky130_fd_sc_hd__decap_4
Xclkbuf_3_5__f_clk clknet_0_clk VGND VGND VPWR VPWR clknet_3_5__leaf_clk sky130_fd_sc_hd__clkbuf_16
XFILLER_0_29_461 VGND VGND VPWR VPWR sky130_fd_sc_hd__decap_3
X_2978_ current_voting_frame\[3\] VGND VGND VPWR VPWR _0657_ sky130_fd_sc_hd__clkbuf_4
X_4717_ clknet_leaf_56_clk _0067_ tree_instances\[0\].u_tree.rst_n VGND VGND VPWR
+ VPWR tree_instances\[2\].u_tree.tree_state\[0\] sky130_fd_sc_hd__dfstp_1
XFILLER_0_71_272 VGND VGND VPWR VPWR sky130_fd_sc_hd__fill_2
X_4648_ clknet_leaf_67_clk _0030_ net9 VGND VGND VPWR VPWR tree_instances\[3\].u_tree.tree_state\[2\]
+ sky130_fd_sc_hd__dfrtp_1
XANTENNA__4840__RESET_B net10 VGND VGND VPWR VPWR sky130_fd_sc_hd__diode_2
XFILLER_0_44_497 VGND VGND VPWR VPWR sky130_fd_sc_hd__fill_2
XANTENNA__3147__B2 _0714_ VGND VGND VPWR VPWR sky130_fd_sc_hd__diode_2
X_4579_ clknet_leaf_16_clk _0299_ net12 VGND VGND VPWR VPWR tree_instances\[8\].u_tree.pipeline_current_node\[0\]\[5\]
+ sky130_fd_sc_hd__dfrtp_1
XFILLER_0_86_309 VGND VGND VPWR VPWR sky130_fd_sc_hd__decap_8
XFILLER_0_67_501 VGND VGND VPWR VPWR sky130_fd_sc_hd__decap_3
XFILLER_0_79_383 VGND VGND VPWR VPWR sky130_fd_sc_hd__decap_6
XFILLER_0_67_512 VGND VGND VPWR VPWR sky130_fd_sc_hd__decap_8
XFILLER_0_39_225 VGND VGND VPWR VPWR sky130_fd_sc_hd__decap_6
XFILLER_0_54_239 VPWR VGND VPWR VGND sky130_ef_sc_hd__decap_12
XFILLER_0_35_453 VGND VGND VPWR VPWR sky130_fd_sc_hd__decap_8
XFILLER_0_35_464 VGND VGND VPWR VPWR sky130_fd_sc_hd__fill_2
XANTENNA__4581__RESET_B net12 VGND VGND VPWR VPWR sky130_fd_sc_hd__diode_2
XFILLER_0_35_486 VGND VGND VPWR VPWR sky130_fd_sc_hd__fill_2
XFILLER_0_22_136 VGND VGND VPWR VPWR sky130_fd_sc_hd__decap_4
XANTENNA__3138__A1 _0648_ VGND VGND VPWR VPWR sky130_fd_sc_hd__diode_2
XANTENNA__3138__B2 _0686_ VGND VGND VPWR VPWR sky130_fd_sc_hd__diode_2
XANTENNA__4510__RESET_B tree_instances\[0\].u_tree.rst_n VGND VGND VPWR VPWR sky130_fd_sc_hd__diode_2
XFILLER_0_50_489 VGND VGND VPWR VPWR sky130_fd_sc_hd__fill_2
XFILLER_0_30_191 VGND VGND VPWR VPWR sky130_fd_sc_hd__fill_2
XFILLER_0_89_169 VGND VGND VPWR VPWR sky130_fd_sc_hd__decap_4
XTAP_TAPCELL_ROW_74_952 VGND VPWR sky130_fd_sc_hd__tapvpwrvgnd_1
XTAP_TAPCELL_ROW_85_1059 VGND VPWR sky130_fd_sc_hd__tapvpwrvgnd_1
X_3950_ _2002_ _1332_ VGND VGND VPWR VPWR _1336_ sky130_fd_sc_hd__and2_1
XTAP_TAPCELL_ROW_46_665 VGND VPWR sky130_fd_sc_hd__tapvpwrvgnd_1
XFILLER_0_85_353 VGND VGND VPWR VPWR sky130_fd_sc_hd__fill_2
X_2901_ tree_instances\[12\].u_tree.tree_state\[0\] VGND VGND VPWR VPWR _0605_ sky130_fd_sc_hd__inv_2
XFILLER_0_58_545 VGND VGND VPWR VPWR sky130_fd_sc_hd__decap_3
XTAP_TAPCELL_ROW_18_389 VGND VPWR sky130_fd_sc_hd__tapvpwrvgnd_1
XFILLER_0_85_386 VGND VGND VPWR VPWR sky130_fd_sc_hd__decap_6
X_3881_ _1290_ VGND VGND VPWR VPWR _1291_ sky130_fd_sc_hd__clkbuf_1
XFILLER_0_45_228 VGND VGND VPWR VPWR sky130_fd_sc_hd__fill_1
X_2832_ _1639_ VGND VGND VPWR VPWR _2135_ sky130_fd_sc_hd__clkbuf_1
XFILLER_0_38_280 VGND VGND VPWR VPWR sky130_fd_sc_hd__fill_1
XANTENNA__4669__RESET_B tree_instances\[0\].u_tree.rst_n VGND VGND VPWR VPWR sky130_fd_sc_hd__diode_2
X_2763_ tree_instances\[8\].u_tree.pipeline_current_node\[0\]\[4\] VGND VGND VPWR
+ VPWR _2071_ sky130_fd_sc_hd__clkbuf_1
XFILLER_0_26_475 VGND VGND VPWR VPWR sky130_fd_sc_hd__fill_1
XFILLER_0_13_125 VGND VGND VPWR VPWR sky130_fd_sc_hd__decap_3
X_4502_ clknet_leaf_53_clk _0233_ tree_instances\[0\].u_tree.rst_n VGND VGND VPWR
+ VPWR tree_instances\[5\].u_tree.pipeline_current_node\[0\]\[2\] sky130_fd_sc_hd__dfrtp_1
XTAP_TAPCELL_ROW_96_1177 VGND VPWR sky130_fd_sc_hd__tapvpwrvgnd_1
XTAP_TAPCELL_ROW_96_1166 VGND VPWR sky130_fd_sc_hd__tapvpwrvgnd_1
X_2694_ _2008_ VGND VGND VPWR VPWR _2013_ sky130_fd_sc_hd__clkbuf_1
XANTENNA__3129__B2 _0696_ VGND VGND VPWR VPWR sky130_fd_sc_hd__diode_2
XANTENNA__3129__A1 _0704_ VGND VGND VPWR VPWR sky130_fd_sc_hd__diode_2
XFILLER_0_13_169 VGND VGND VPWR VPWR sky130_fd_sc_hd__fill_2
XFILLER_0_1_553 VGND VGND VPWR VPWR sky130_fd_sc_hd__decap_6
X_4433_ clknet_leaf_58_clk _0179_ net12 VGND VGND VPWR VPWR tree_instances\[2\].u_tree.pipeline_frame_id\[0\]\[2\]
+ sky130_fd_sc_hd__dfrtp_1
XFILLER_0_67_30 VGND VGND VPWR VPWR sky130_fd_sc_hd__fill_1
X_4364_ clknet_leaf_6_clk _0124_ tree_instances\[0\].u_tree.rst_n VGND VGND VPWR VPWR
+ current_voting_frame\[3\] sky130_fd_sc_hd__dfrtp_2
X_3315_ _0946_ VGND VGND VPWR VPWR _0156_ sky130_fd_sc_hd__clkbuf_1
X_4295_ _1530_ VGND VGND VPWR VPWR _0552_ sky130_fd_sc_hd__clkbuf_1
XFILLER_0_67_63 VPWR VGND VPWR VGND sky130_ef_sc_hd__decap_12
X_3246_ _0908_ _0909_ VGND VGND VPWR VPWR _0910_ sky130_fd_sc_hd__and2_1
XFILLER_0_20_3 VPWR VGND VPWR VGND sky130_ef_sc_hd__decap_12
X_3177_ _0660_ tree_instances\[20\].u_tree.frame_id_out\[4\] VGND VGND VPWR VPWR _0849_
+ sky130_fd_sc_hd__or2b_1
XFILLER_0_83_95 VGND VGND VPWR VPWR sky130_fd_sc_hd__fill_2
XFILLER_0_68_309 VGND VGND VPWR VPWR sky130_fd_sc_hd__fill_2
XANTENNA__4618__SET_B net12 VGND VGND VPWR VPWR sky130_fd_sc_hd__diode_2
XFILLER_0_88_180 VGND VGND VPWR VPWR sky130_fd_sc_hd__fill_2
XFILLER_0_36_206 VGND VGND VPWR VPWR sky130_fd_sc_hd__fill_2
XFILLER_0_8_185 VGND VGND VPWR VPWR sky130_fd_sc_hd__decap_3
XANTENNA__4339__RESET_B net10 VGND VGND VPWR VPWR sky130_fd_sc_hd__diode_2
XFILLER_0_44_250 VGND VGND VPWR VPWR sky130_fd_sc_hd__fill_2
XFILLER_0_17_497 VGND VGND VPWR VPWR sky130_fd_sc_hd__decap_6
XFILLER_0_32_401 VPWR VGND VPWR VGND sky130_ef_sc_hd__decap_12
XTAP_TAPCELL_ROW_9_302 VGND VPWR sky130_fd_sc_hd__tapvpwrvgnd_1
XANTENNA__2983__A _0660_ VGND VGND VPWR VPWR sky130_fd_sc_hd__diode_2
XTAP_TAPCELL_ROW_71_922 VGND VPWR sky130_fd_sc_hd__tapvpwrvgnd_1
XTAP_TAPCELL_ROW_43_635 VGND VPWR sky130_fd_sc_hd__tapvpwrvgnd_1
XFILLER_0_94_161 VGND VGND VPWR VPWR sky130_fd_sc_hd__fill_2
XTAP_TAPCELL_ROW_15_359 VGND VPWR sky130_fd_sc_hd__tapvpwrvgnd_1
XANTENNA__4762__RESET_B net10 VGND VGND VPWR VPWR sky130_fd_sc_hd__diode_2
XFILLER_0_82_356 VGND VGND VPWR VPWR sky130_fd_sc_hd__decap_8
XFILLER_0_42_209 VPWR VGND VPWR VGND sky130_ef_sc_hd__decap_12
XFILLER_0_88_29 VGND VGND VPWR VPWR sky130_fd_sc_hd__decap_8
XFILLER_0_50_242 VGND VGND VPWR VPWR sky130_fd_sc_hd__decap_6
XFILLER_0_50_253 VPWR VGND VPWR VGND sky130_ef_sc_hd__decap_12
XANTENNA__3531__A1 _0665_ VGND VGND VPWR VPWR sky130_fd_sc_hd__diode_2
X_3100_ _0697_ tree_instances\[1\].u_tree.frame_id_out\[4\] _0766_ _0771_ VGND VGND
+ VPWR VPWR _0772_ sky130_fd_sc_hd__o211a_1
XFILLER_0_37_22 VGND VGND VPWR VPWR sky130_fd_sc_hd__fill_1
X_4080_ _2064_ _1399_ VGND VGND VPWR VPWR _1403_ sky130_fd_sc_hd__and2_1
XFILLER_0_37_55 VGND VGND VPWR VPWR sky130_fd_sc_hd__fill_1
X_3031_ _0653_ VGND VGND VPWR VPWR _0703_ sky130_fd_sc_hd__inv_2
XFILLER_0_85_161 VGND VGND VPWR VPWR sky130_fd_sc_hd__fill_2
XFILLER_0_18_206 VGND VGND VPWR VPWR sky130_fd_sc_hd__fill_2
X_3933_ _1322_ VGND VGND VPWR VPWR _1323_ sky130_fd_sc_hd__clkbuf_1
X_3864_ _1595_ _1091_ _0608_ tree_instances\[11\].u_tree.ready_for_next VGND VGND
+ VPWR VPWR _0376_ sky130_fd_sc_hd__a22o_1
XFILLER_0_73_378 VPWR VGND VPWR VGND sky130_ef_sc_hd__decap_12
XPHY_EDGE_ROW_12_Left_109 VGND VGND VPWR VPWR sky130_fd_sc_hd__decap_3
XFILLER_0_5_111 VGND VGND VPWR VPWR sky130_fd_sc_hd__fill_1
X_2815_ _1840_ VGND VGND VPWR VPWR _2119_ sky130_fd_sc_hd__clkbuf_1
XANTENNA__4432__RESET_B net13 VGND VGND VPWR VPWR sky130_fd_sc_hd__diode_2
XFILLER_0_33_209 VGND VGND VPWR VPWR sky130_fd_sc_hd__decap_8
XFILLER_0_14_401 VPWR VGND VPWR VGND sky130_ef_sc_hd__decap_12
XFILLER_0_5_155 VPWR VGND VPWR VGND sky130_ef_sc_hd__decap_12
XFILLER_0_26_250 VGND VGND VPWR VPWR sky130_fd_sc_hd__fill_2
X_3795_ _1240_ VGND VGND VPWR VPWR _0342_ sky130_fd_sc_hd__clkbuf_1
XFILLER_0_54_570 VGND VGND VPWR VPWR sky130_fd_sc_hd__decap_4
X_2746_ _2056_ VGND VGND VPWR VPWR _2057_ sky130_fd_sc_hd__clkbuf_1
XFILLER_0_14_489 VPWR VGND VPWR VGND sky130_ef_sc_hd__decap_12
X_2677_ _1997_ VGND VGND VPWR VPWR _1998_ sky130_fd_sc_hd__clkbuf_1
X_4416_ clknet_leaf_22_clk _0163_ net11 VGND VGND VPWR VPWR tree_instances\[1\].u_tree.frame_id_out\[2\]
+ sky130_fd_sc_hd__dfrtp_1
XPHY_EDGE_ROW_21_Left_118 VGND VGND VPWR VPWR sky130_fd_sc_hd__decap_3
X_4347_ clknet_leaf_12_clk _0107_ tree_instances\[0\].u_tree.rst_n VGND VGND VPWR
+ VPWR net3 sky130_fd_sc_hd__dfrtp_1
X_4278_ _1521_ VGND VGND VPWR VPWR _0544_ sky130_fd_sc_hd__clkbuf_1
XFILLER_0_94_83 VGND VGND VPWR VPWR sky130_fd_sc_hd__fill_1
X_3229_ _0896_ _0897_ VGND VGND VPWR VPWR _0898_ sky130_fd_sc_hd__nand2_1
XFILLER_0_68_139 VGND VGND VPWR VPWR sky130_fd_sc_hd__fill_1
XFILLER_0_76_194 VGND VGND VPWR VPWR sky130_fd_sc_hd__fill_2
XFILLER_0_76_172 VGND VGND VPWR VPWR sky130_fd_sc_hd__fill_2
XPHY_EDGE_ROW_30_Left_127 VGND VGND VPWR VPWR sky130_fd_sc_hd__decap_3
XTAP_TAPCELL_ROW_40_605 VGND VPWR sky130_fd_sc_hd__tapvpwrvgnd_1
XFILLER_0_64_345 VGND VGND VPWR VPWR sky130_fd_sc_hd__fill_2
XTAP_TAPCELL_ROW_12_329 VGND VPWR sky130_fd_sc_hd__tapvpwrvgnd_1
XFILLER_0_64_389 VPWR VGND VPWR VGND sky130_ef_sc_hd__decap_12
XFILLER_0_60_573 VGND VGND VPWR VPWR sky130_fd_sc_hd__fill_1
XFILLER_0_20_448 VGND VGND VPWR VPWR sky130_fd_sc_hd__fill_2
XFILLER_0_90_19 VGND VGND VPWR VPWR sky130_fd_sc_hd__decap_8
XFILLER_0_59_117 VGND VGND VPWR VPWR sky130_fd_sc_hd__decap_4
XFILLER_0_59_106 VGND VGND VPWR VPWR sky130_fd_sc_hd__fill_1
XTAP_TAPCELL_ROW_82_1029 VGND VPWR sky130_fd_sc_hd__tapvpwrvgnd_1
XTAP_TAPCELL_ROW_28_484 VGND VPWR sky130_fd_sc_hd__tapvpwrvgnd_1
XANTENNA__2218__A _1575_ VGND VGND VPWR VPWR sky130_fd_sc_hd__diode_2
XTAP_TAPCELL_ROW_56_771 VGND VPWR sky130_fd_sc_hd__tapvpwrvgnd_1
XFILLER_0_67_161 VGND VGND VPWR VPWR sky130_fd_sc_hd__decap_6
XFILLER_0_23_57 VGND VGND VPWR VPWR sky130_fd_sc_hd__fill_1
XFILLER_0_55_334 VGND VGND VPWR VPWR sky130_fd_sc_hd__fill_2
XFILLER_0_70_304 VGND VGND VPWR VPWR sky130_fd_sc_hd__fill_1
X_3580_ _1705_ VGND VGND VPWR VPWR _1111_ sky130_fd_sc_hd__clkbuf_1
XANTENNA_clkbuf_leaf_20_clk_A clknet_3_3__leaf_clk VGND VGND VPWR VPWR sky130_fd_sc_hd__diode_2
XFILLER_0_82_197 VGND VGND VPWR VPWR sky130_fd_sc_hd__fill_2
X_2600_ _1927_ _1897_ _1931_ tree_instances\[20\].u_tree.tree_state\[2\] VGND VGND
+ VPWR VPWR _0025_ sky130_fd_sc_hd__o31a_1
X_2531_ _1684_ tree_instances\[7\].u_tree.tree_state\[2\] VGND VGND VPWR VPWR _1873_
+ sky130_fd_sc_hd__and2b_1
XFILLER_0_51_573 VGND VGND VPWR VPWR sky130_fd_sc_hd__fill_1
XTAP_TAPCELL_ROW_93_1136 VGND VPWR sky130_fd_sc_hd__tapvpwrvgnd_1
XANTENNA_clkbuf_leaf_35_clk_A clknet_3_7__leaf_clk VGND VGND VPWR VPWR sky130_fd_sc_hd__diode_2
X_2462_ tree_instances\[4\].u_tree.pipeline_current_node\[0\]\[3\] VGND VGND VPWR
+ VPWR _1813_ sky130_fd_sc_hd__clkbuf_1
X_4201_ _1431_ _1478_ VGND VGND VPWR VPWR _1482_ sky130_fd_sc_hd__and2_1
X_2393_ tree_instances\[6\].u_tree.tree_state\[0\] _1751_ VGND VGND VPWR VPWR _1752_
+ sky130_fd_sc_hd__and2_1
X_4132_ _1908_ _1437_ _0026_ tree_instances\[20\].u_tree.pipeline_valid\[0\] VGND
+ VGND VPWR VPWR _0482_ sky130_fd_sc_hd__o2bb2a_1
XFILLER_0_64_20 VGND VGND VPWR VPWR sky130_fd_sc_hd__fill_1
XFILLER_0_3_45 VGND VGND VPWR VPWR sky130_fd_sc_hd__decap_8
X_4063_ _1393_ VGND VGND VPWR VPWR _0457_ sky130_fd_sc_hd__clkbuf_1
X_3014_ _0685_ VGND VGND VPWR VPWR _0686_ sky130_fd_sc_hd__clkbuf_4
XFILLER_0_64_75 VGND VGND VPWR VPWR sky130_fd_sc_hd__decap_6
XANTENNA__4684__RESET_B net11 VGND VGND VPWR VPWR sky130_fd_sc_hd__diode_2
XANTENNA__4613__RESET_B net12 VGND VGND VPWR VPWR sky130_fd_sc_hd__diode_2
X_3916_ _1310_ VGND VGND VPWR VPWR _0393_ sky130_fd_sc_hd__clkbuf_1
XFILLER_0_80_85 VPWR VGND VPWR VGND sky130_ef_sc_hd__decap_12
X_4896_ clknet_leaf_25_clk _0567_ net11 VGND VGND VPWR VPWR state\[0\] sky130_fd_sc_hd__dfrtp_1
XFILLER_0_46_345 VGND VGND VPWR VPWR sky130_fd_sc_hd__decap_4
X_3847_ _1267_ VGND VGND VPWR VPWR _0367_ sky130_fd_sc_hd__clkbuf_1
XFILLER_0_6_475 VGND VGND VPWR VPWR sky130_fd_sc_hd__fill_1
X_3778_ tree_instances\[10\].u_tree.tree_state\[1\] tree_instances\[10\].u_tree.tree_state\[2\]
+ _0618_ VGND VGND VPWR VPWR _1231_ sky130_fd_sc_hd__or3_1
X_2729_ tree_instances\[8\].u_tree.prediction_valid _1668_ VGND VGND VPWR VPWR _2043_
+ sky130_fd_sc_hd__and2b_1
XFILLER_0_14_253 VGND VGND VPWR VPWR sky130_fd_sc_hd__decap_8
XFILLER_0_10_492 VPWR VGND VPWR VGND sky130_ef_sc_hd__decap_12
XPHY_EDGE_ROW_29_Right_29 VGND VGND VPWR VPWR sky130_fd_sc_hd__decap_3
XANTENNA__4354__RESET_B net13 VGND VGND VPWR VPWR sky130_fd_sc_hd__diode_2
XTAP_TAPCELL_ROW_53_741 VGND VPWR sky130_fd_sc_hd__tapvpwrvgnd_1
XTAP_TAPCELL_ROW_25_454 VGND VPWR sky130_fd_sc_hd__tapvpwrvgnd_1
XFILLER_0_92_462 VPWR VGND VPWR VGND sky130_ef_sc_hd__decap_12
XFILLER_0_64_186 VGND VGND VPWR VPWR sky130_fd_sc_hd__fill_1
XANTENNA__3982__B2 tree_instances\[13\].u_tree.ready_for_next VGND VGND VPWR VPWR
+ sky130_fd_sc_hd__diode_2
XPHY_EDGE_ROW_38_Right_38 VGND VGND VPWR VPWR sky130_fd_sc_hd__decap_3
XFILLER_0_52_304 VGND VGND VPWR VPWR sky130_fd_sc_hd__fill_2
XFILLER_0_64_197 VPWR VGND VPWR VGND sky130_ef_sc_hd__decap_12
XFILLER_0_33_540 VGND VGND VPWR VPWR sky130_fd_sc_hd__fill_1
XFILLER_0_52_337 VPWR VGND VPWR VGND sky130_ef_sc_hd__decap_12
XFILLER_0_20_267 VGND VGND VPWR VPWR sky130_fd_sc_hd__fill_2
XFILLER_0_18_68 VGND VGND VPWR VPWR sky130_fd_sc_hd__decap_8
XPHY_EDGE_ROW_47_Right_47 VGND VGND VPWR VPWR sky130_fd_sc_hd__decap_3
XFILLER_0_87_256 VGND VGND VPWR VPWR sky130_fd_sc_hd__fill_2
XFILLER_0_28_334 VPWR VGND VPWR VGND sky130_ef_sc_hd__decap_12
X_4750_ clknet_leaf_41_clk _0447_ net10 VGND VGND VPWR VPWR tree_instances\[15\].u_tree.pipeline_current_node\[0\]\[6\]
+ sky130_fd_sc_hd__dfrtp_1
XPHY_EDGE_ROW_56_Right_56 VGND VGND VPWR VPWR sky130_fd_sc_hd__decap_3
X_4681_ clknet_leaf_17_clk _0385_ net11 VGND VGND VPWR VPWR tree_instances\[12\].u_tree.pipeline_current_node\[0\]\[7\]
+ sky130_fd_sc_hd__dfrtp_1
XFILLER_0_83_473 VPWR VGND VPWR VGND sky130_ef_sc_hd__decap_12
X_3701_ _1187_ VGND VGND VPWR VPWR _0301_ sky130_fd_sc_hd__clkbuf_1
XFILLER_0_16_529 VGND VGND VPWR VPWR sky130_fd_sc_hd__decap_3
XFILLER_0_43_315 VGND VGND VPWR VPWR sky130_fd_sc_hd__decap_4
X_3632_ tree_instances\[7\].u_tree.pipeline_current_node\[0\]\[2\] VGND VGND VPWR
+ VPWR _1144_ sky130_fd_sc_hd__clkbuf_1
XFILLER_0_43_337 VGND VGND VPWR VPWR sky130_fd_sc_hd__fill_2
XFILLER_0_43_359 VGND VGND VPWR VPWR sky130_fd_sc_hd__fill_1
XFILLER_0_50_77 VGND VGND VPWR VPWR sky130_fd_sc_hd__fill_2
XFILLER_0_24_573 VGND VGND VPWR VPWR sky130_fd_sc_hd__fill_1
X_3563_ _1097_ VGND VGND VPWR VPWR _0253_ sky130_fd_sc_hd__clkbuf_1
XFILLER_0_11_223 VGND VGND VPWR VPWR sky130_fd_sc_hd__fill_1
X_3494_ tree_instances\[5\].u_tree.pipeline_current_node\[0\]\[0\] VGND VGND VPWR
+ VPWR _1051_ sky130_fd_sc_hd__clkbuf_1
X_2514_ tree_instances\[13\].u_tree.pipeline_current_node\[0\]\[5\] VGND VGND VPWR
+ VPWR _1859_ sky130_fd_sc_hd__clkbuf_1
XPHY_EDGE_ROW_65_Right_65 VGND VGND VPWR VPWR sky130_fd_sc_hd__decap_3
XFILLER_0_11_267 VGND VGND VPWR VPWR sky130_fd_sc_hd__fill_1
X_2445_ _1797_ VGND VGND VPWR VPWR _1798_ sky130_fd_sc_hd__clkbuf_1
X_2376_ _1735_ _1736_ VGND VGND VPWR VPWR _1737_ sky130_fd_sc_hd__nor2_1
X_4115_ _1420_ VGND VGND VPWR VPWR _1421_ sky130_fd_sc_hd__clkbuf_1
XFILLER_0_75_96 VGND VGND VPWR VPWR sky130_fd_sc_hd__fill_2
XANTENNA__4865__RESET_B net13 VGND VGND VPWR VPWR sky130_fd_sc_hd__diode_2
XFILLER_0_78_201 VPWR VGND VPWR VGND sky130_ef_sc_hd__decap_12
XTAP_TAPCELL_ROW_67_877 VGND VPWR sky130_fd_sc_hd__tapvpwrvgnd_1
XANTENNA__3036__A1_N _0646_ VGND VGND VPWR VPWR sky130_fd_sc_hd__diode_2
X_4046_ _1688_ _1375_ VGND VGND VPWR VPWR _1385_ sky130_fd_sc_hd__and2_1
XFILLER_0_91_40 VGND VGND VPWR VPWR sky130_fd_sc_hd__fill_1
XFILLER_0_78_234 VPWR VGND VPWR VGND sky130_ef_sc_hd__decap_12
XFILLER_0_93_204 VGND VGND VPWR VPWR sky130_fd_sc_hd__fill_1
XFILLER_0_66_418 VGND VGND VPWR VPWR sky130_fd_sc_hd__fill_2
XFILLER_0_38_109 VGND VGND VPWR VPWR sky130_fd_sc_hd__decap_8
XPHY_EDGE_ROW_74_Right_74 VGND VGND VPWR VPWR sky130_fd_sc_hd__decap_3
XTAP_TAPCELL_ROW_22_424 VGND VPWR sky130_fd_sc_hd__tapvpwrvgnd_1
XTAP_TAPCELL_ROW_50_711 VGND VPWR sky130_fd_sc_hd__tapvpwrvgnd_1
X_4879_ clknet_leaf_38_clk _0551_ net10 VGND VGND VPWR VPWR tree_instances\[20\].u_tree.pipeline_current_node\[0\]\[4\]
+ sky130_fd_sc_hd__dfrtp_1
XANTENNA__3964__A1 _1124_ VGND VGND VPWR VPWR sky130_fd_sc_hd__diode_2
XFILLER_0_61_145 VGND VGND VPWR VPWR sky130_fd_sc_hd__decap_4
XFILLER_0_6_250 VGND VGND VPWR VPWR sky130_fd_sc_hd__fill_2
XFILLER_0_46_197 VPWR VGND VPWR VGND sky130_ef_sc_hd__decap_12
XFILLER_0_6_283 VPWR VGND VPWR VGND sky130_ef_sc_hd__decap_12
XFILLER_0_15_573 VGND VGND VPWR VPWR sky130_fd_sc_hd__fill_1
XFILLER_0_42_381 VGND VGND VPWR VPWR sky130_fd_sc_hd__fill_2
XPHY_EDGE_ROW_83_Right_83 VGND VGND VPWR VPWR sky130_fd_sc_hd__decap_3
XANTENNA__4535__RESET_B net11 VGND VGND VPWR VPWR sky130_fd_sc_hd__diode_2
XPHY_EDGE_ROW_92_Right_92 VGND VGND VPWR VPWR sky130_fd_sc_hd__decap_3
XFILLER_0_69_267 VPWR VGND VPWR VGND sky130_ef_sc_hd__decap_12
XTAP_TAPCELL_ROW_38_590 VGND VPWR sky130_fd_sc_hd__tapvpwrvgnd_1
XFILLER_0_84_226 VGND VGND VPWR VPWR sky130_fd_sc_hd__fill_2
XFILLER_0_57_429 VPWR VGND VPWR VGND sky130_ef_sc_hd__decap_12
XFILLER_0_80_421 VGND VGND VPWR VPWR sky130_fd_sc_hd__fill_2
XFILLER_0_25_337 VGND VGND VPWR VPWR sky130_fd_sc_hd__decap_8
XFILLER_0_96_29 VPWR VGND VPWR VGND sky130_ef_sc_hd__decap_12
XTAP_TAPCELL_ROW_90_1106 VGND VPWR sky130_fd_sc_hd__tapvpwrvgnd_1
XFILLER_0_0_437 VGND VGND VPWR VPWR sky130_fd_sc_hd__fill_1
XFILLER_0_29_34 VGND VGND VPWR VPWR sky130_fd_sc_hd__fill_2
X_2230_ _1606_ VGND VGND VPWR VPWR _1607_ sky130_fd_sc_hd__clkbuf_1
XANTENNA__3062__A _0653_ VGND VGND VPWR VPWR sky130_fd_sc_hd__diode_2
XFILLER_0_45_55 VGND VGND VPWR VPWR sky130_fd_sc_hd__fill_1
XFILLER_0_88_543 VPWR VGND VPWR VGND sky130_ef_sc_hd__decap_12
XTAP_TAPCELL_ROW_64_847 VGND VPWR sky130_fd_sc_hd__tapvpwrvgnd_1
XFILLER_0_75_237 VGND VGND VPWR VPWR sky130_fd_sc_hd__decap_6
XFILLER_0_0_57 VPWR VGND VPWR VGND sky130_ef_sc_hd__decap_12
X_2994_ tree_instances\[0\].u_tree.frame_id_in\[0\] _0669_ VGND VGND VPWR VPWR _0671_
+ sky130_fd_sc_hd__and2_1
X_4802_ clknet_leaf_54_clk _0489_ tree_instances\[0\].u_tree.rst_n VGND VGND VPWR
+ VPWR tree_instances\[17\].u_tree.pipeline_current_node\[0\]\[6\] sky130_fd_sc_hd__dfrtp_1
XFILLER_0_56_440 VGND VGND VPWR VPWR sky130_fd_sc_hd__decap_4
X_4733_ clknet_leaf_24_clk _0431_ net11 VGND VGND VPWR VPWR tree_instances\[14\].u_tree.pipeline_frame_id\[0\]\[2\]
+ sky130_fd_sc_hd__dfrtp_1
XFILLER_0_28_153 VPWR VGND VPWR VGND sky130_ef_sc_hd__decap_12
XFILLER_0_28_197 VGND VGND VPWR VPWR sky130_fd_sc_hd__decap_6
XFILLER_0_9_55 VGND VGND VPWR VPWR sky130_fd_sc_hd__fill_1
X_4664_ clknet_leaf_11_clk _0369_ tree_instances\[0\].u_tree.rst_n VGND VGND VPWR
+ VPWR tree_instances\[11\].u_tree.pipeline_frame_id\[0\]\[3\] sky130_fd_sc_hd__dfrtp_1
X_3615_ _1132_ VGND VGND VPWR VPWR _0270_ sky130_fd_sc_hd__clkbuf_1
XFILLER_0_12_510 VPWR VGND VPWR VGND sky130_ef_sc_hd__decap_12
XFILLER_0_3_231 VGND VGND VPWR VPWR sky130_fd_sc_hd__fill_2
X_4595_ clknet_leaf_63_clk _0071_ tree_instances\[0\].u_tree.rst_n VGND VGND VPWR
+ VPWR tree_instances\[4\].u_tree.tree_state\[0\] sky130_fd_sc_hd__dfstp_1
XFILLER_0_24_381 VPWR VGND VPWR VGND sky130_ef_sc_hd__decap_12
XFILLER_0_43_178 VGND VGND VPWR VPWR sky130_fd_sc_hd__decap_3
XFILLER_0_10_91 VPWR VGND VPWR VGND sky130_ef_sc_hd__decap_12
X_3546_ _1086_ VGND VGND VPWR VPWR _0247_ sky130_fd_sc_hd__clkbuf_1
XFILLER_0_86_51 VGND VGND VPWR VPWR sky130_fd_sc_hd__decap_8
X_3477_ _1042_ VGND VGND VPWR VPWR _0222_ sky130_fd_sc_hd__clkbuf_1
XFILLER_0_50_3 VPWR VGND VPWR VGND sky130_ef_sc_hd__decap_12
X_2428_ _1776_ _1781_ VGND VGND VPWR VPWR _1782_ sky130_fd_sc_hd__nand2_1
X_2359_ tree_instances\[13\].u_tree.pipeline_current_node\[0\]\[1\] VGND VGND VPWR
+ VPWR _1722_ sky130_fd_sc_hd__clkbuf_1
X_4029_ _1375_ VGND VGND VPWR VPWR _1376_ sky130_fd_sc_hd__dlymetal6s2s_1
XFILLER_0_66_226 VGND VGND VPWR VPWR sky130_fd_sc_hd__fill_2
XFILLER_0_94_557 VPWR VGND VPWR VGND sky130_ef_sc_hd__decap_12
XANTENNA__4007__S _0012_ VGND VGND VPWR VPWR sky130_fd_sc_hd__diode_2
XTAP_TAPCELL_ROW_35_560 VGND VPWR sky130_fd_sc_hd__tapvpwrvgnd_1
XFILLER_0_81_229 VGND VGND VPWR VPWR sky130_fd_sc_hd__decap_8
XFILLER_0_19_164 VGND VGND VPWR VPWR sky130_fd_sc_hd__decap_4
XFILLER_0_74_281 VPWR VGND VPWR VGND sky130_ef_sc_hd__decap_12
XFILLER_0_62_421 VGND VGND VPWR VPWR sky130_fd_sc_hd__decap_8
XFILLER_0_30_351 VGND VGND VPWR VPWR sky130_fd_sc_hd__fill_1
XANTENNA__4787__RESET_B net10 VGND VGND VPWR VPWR sky130_fd_sc_hd__diode_2
XTAP_TAPCELL_ROW_7_274 VGND VPWR sky130_fd_sc_hd__tapvpwrvgnd_1
XANTENNA__4716__RESET_B net9 VGND VGND VPWR VPWR sky130_fd_sc_hd__diode_2
XFILLER_0_85_513 VGND VGND VPWR VPWR sky130_fd_sc_hd__fill_2
XTAP_TAPCELL_ROW_61_817 VGND VPWR sky130_fd_sc_hd__tapvpwrvgnd_1
XFILLER_0_57_215 VGND VGND VPWR VPWR sky130_fd_sc_hd__fill_2
XFILLER_0_57_259 VPWR VGND VPWR VGND sky130_ef_sc_hd__decap_12
XFILLER_0_57_237 VGND VGND VPWR VPWR sky130_fd_sc_hd__decap_3
XFILLER_0_38_473 VGND VGND VPWR VPWR sky130_fd_sc_hd__decap_3
XFILLER_0_65_292 VGND VGND VPWR VPWR sky130_fd_sc_hd__decap_3
XFILLER_0_65_281 VGND VGND VPWR VPWR sky130_fd_sc_hd__decap_8
XFILLER_0_5_529 VPWR VGND VPWR VGND sky130_ef_sc_hd__decap_12
XANTENNA__3756__S _0042_ VGND VGND VPWR VPWR sky130_fd_sc_hd__diode_2
XFILLER_0_80_262 VGND VGND VPWR VPWR sky130_fd_sc_hd__fill_2
XFILLER_0_80_251 VGND VGND VPWR VPWR sky130_fd_sc_hd__fill_1
XFILLER_0_25_167 VGND VGND VPWR VPWR sky130_fd_sc_hd__fill_1
XFILLER_0_53_476 VGND VGND VPWR VPWR sky130_fd_sc_hd__fill_2
XFILLER_0_13_329 VGND VGND VPWR VPWR sky130_fd_sc_hd__decap_6
X_4380_ clknet_leaf_36_clk _0128_ net10 VGND VGND VPWR VPWR tree_instances\[0\].u_tree.pipeline_current_node\[0\]\[2\]
+ sky130_fd_sc_hd__dfrtp_1
X_3400_ _2115_ _0996_ VGND VGND VPWR VPWR _0998_ sky130_fd_sc_hd__and2_1
XFILLER_0_40_159 VGND VGND VPWR VPWR sky130_fd_sc_hd__fill_2
X_3331_ _0954_ VGND VGND VPWR VPWR _0164_ sky130_fd_sc_hd__clkbuf_1
XFILLER_0_21_351 VGND VGND VPWR VPWR sky130_fd_sc_hd__fill_2
X_3262_ _0918_ VGND VGND VPWR VPWR _0131_ sky130_fd_sc_hd__clkbuf_1
XANTENNA__4457__RESET_B net9 VGND VGND VPWR VPWR sky130_fd_sc_hd__diode_2
X_2213_ _1592_ tree_instances\[9\].u_tree.tree_state\[2\] VGND VGND VPWR VPWR _1593_
+ sky130_fd_sc_hd__and2b_1
X_3193_ _0653_ tree_instances\[13\].u_tree.frame_id_out\[2\] VGND VGND VPWR VPWR _0865_
+ sky130_fd_sc_hd__xnor2_1
XFILLER_0_56_65 VPWR VGND VPWR VGND sky130_ef_sc_hd__decap_12
XTAP_TAPCELL_ROW_77_983 VGND VPWR sky130_fd_sc_hd__tapvpwrvgnd_1
XFILLER_0_22_7 VGND VGND VPWR VPWR sky130_fd_sc_hd__fill_1
XFILLER_0_88_340 VGND VGND VPWR VPWR sky130_fd_sc_hd__decap_4
XTAP_TAPCELL_ROW_49_696 VGND VPWR sky130_fd_sc_hd__tapvpwrvgnd_1
XFILLER_0_48_226 VGND VGND VPWR VPWR sky130_fd_sc_hd__decap_3
XFILLER_0_63_207 VGND VGND VPWR VPWR sky130_fd_sc_hd__fill_2
XTAP_TAPCELL_ROW_32_530 VGND VPWR sky130_fd_sc_hd__tapvpwrvgnd_1
X_2977_ _0656_ VGND VGND VPWR VPWR _0108_ sky130_fd_sc_hd__clkbuf_1
XFILLER_0_56_270 VGND VGND VPWR VPWR sky130_fd_sc_hd__decap_8
XFILLER_0_16_134 VGND VGND VPWR VPWR sky130_fd_sc_hd__decap_4
XFILLER_0_16_145 VGND VGND VPWR VPWR sky130_fd_sc_hd__fill_1
X_4716_ clknet_leaf_4_clk _0089_ net9 VGND VGND VPWR VPWR tree_instances\[13\].u_tree.prediction_valid
+ sky130_fd_sc_hd__dfrtp_1
XFILLER_0_71_295 VGND VGND VPWR VPWR sky130_fd_sc_hd__fill_1
X_4647_ clknet_leaf_67_clk _0029_ net9 VGND VGND VPWR VPWR tree_instances\[3\].u_tree.tree_state\[1\]
+ sky130_fd_sc_hd__dfrtp_1
XFILLER_0_4_573 VGND VGND VPWR VPWR sky130_fd_sc_hd__fill_1
XFILLER_0_31_137 VGND VGND VPWR VPWR sky130_fd_sc_hd__decap_8
X_4578_ clknet_leaf_15_clk _0298_ net12 VGND VGND VPWR VPWR tree_instances\[8\].u_tree.pipeline_current_node\[0\]\[4\]
+ sky130_fd_sc_hd__dfrtp_1
XFILLER_0_12_351 VGND VGND VPWR VPWR sky130_fd_sc_hd__fill_2
XANTENNA__4880__RESET_B net10 VGND VGND VPWR VPWR sky130_fd_sc_hd__diode_2
X_3529_ tree_instances\[5\].u_tree.pipeline_current_node\[0\]\[8\] _1053_ VGND VGND
+ VPWR VPWR _1078_ sky130_fd_sc_hd__and2_1
XTAP_TAPCELL_ROW_4_244 VGND VPWR sky130_fd_sc_hd__tapvpwrvgnd_1
XFILLER_0_79_373 VGND VGND VPWR VPWR sky130_fd_sc_hd__fill_2
XANTENNA__3083__A1 _0691_ VGND VGND VPWR VPWR sky130_fd_sc_hd__diode_2
XFILLER_0_94_321 VGND VGND VPWR VPWR sky130_fd_sc_hd__fill_1
XFILLER_0_62_251 VGND VGND VPWR VPWR sky130_fd_sc_hd__fill_1
XFILLER_0_62_273 VGND VGND VPWR VPWR sky130_fd_sc_hd__fill_2
XFILLER_0_35_498 VGND VGND VPWR VPWR sky130_fd_sc_hd__fill_1
XFILLER_0_50_402 VPWR VGND VPWR VGND sky130_ef_sc_hd__decap_12
XFILLER_0_30_170 VGND VGND VPWR VPWR sky130_fd_sc_hd__decap_3
XANTENNA__4550__RESET_B net13 VGND VGND VPWR VPWR sky130_fd_sc_hd__diode_2
XFILLER_0_89_104 VGND VGND VPWR VPWR sky130_fd_sc_hd__decap_4
XTAP_TAPCELL_ROW_74_953 VGND VPWR sky130_fd_sc_hd__tapvpwrvgnd_1
XANTENNA__3074__A1 _0714_ VGND VGND VPWR VPWR sky130_fd_sc_hd__diode_2
XTAP_TAPCELL_ROW_46_666 VGND VPWR sky130_fd_sc_hd__tapvpwrvgnd_1
XANTENNA__3074__B2 _0691_ VGND VGND VPWR VPWR sky130_fd_sc_hd__diode_2
X_2900_ _0604_ VGND VGND VPWR VPWR _0018_ sky130_fd_sc_hd__inv_2
X_3880_ _1733_ VGND VGND VPWR VPWR _1290_ sky130_fd_sc_hd__clkbuf_1
XFILLER_0_73_505 VGND VGND VPWR VPWR sky130_fd_sc_hd__decap_4
Xclkbuf_leaf_70_clk clknet_3_0__leaf_clk VGND VGND VPWR VPWR clknet_leaf_70_clk sky130_fd_sc_hd__clkbuf_4
X_2831_ _1635_ VGND VGND VPWR VPWR _2134_ sky130_fd_sc_hd__clkbuf_1
XFILLER_0_26_421 VPWR VGND VPWR VGND sky130_ef_sc_hd__decap_12
XFILLER_0_42_89 VGND VGND VPWR VPWR sky130_fd_sc_hd__fill_1
XFILLER_0_5_315 VGND VGND VPWR VPWR sky130_fd_sc_hd__fill_2
X_2762_ _2070_ VGND VGND VPWR VPWR _0089_ sky130_fd_sc_hd__clkbuf_1
X_4501_ clknet_leaf_53_clk _0232_ tree_instances\[0\].u_tree.rst_n VGND VGND VPWR
+ VPWR tree_instances\[5\].u_tree.pipeline_current_node\[0\]\[1\] sky130_fd_sc_hd__dfrtp_1
XTAP_TAPCELL_ROW_96_1167 VGND VPWR sky130_fd_sc_hd__tapvpwrvgnd_1
X_2693_ _1556_ VGND VGND VPWR VPWR _2012_ sky130_fd_sc_hd__clkbuf_1
X_4432_ clknet_leaf_57_clk _0178_ net13 VGND VGND VPWR VPWR tree_instances\[2\].u_tree.pipeline_frame_id\[0\]\[1\]
+ sky130_fd_sc_hd__dfrtp_1
XFILLER_0_41_446 VGND VGND VPWR VPWR sky130_fd_sc_hd__fill_2
XFILLER_0_53_295 VPWR VGND VPWR VGND sky130_ef_sc_hd__decap_12
XTAP_TAPCELL_ROW_96_1178 VGND VPWR sky130_fd_sc_hd__tapvpwrvgnd_1
XANTENNA__4638__RESET_B tree_instances\[0\].u_tree.rst_n VGND VGND VPWR VPWR sky130_fd_sc_hd__diode_2
XFILLER_0_21_181 VGND VGND VPWR VPWR sky130_fd_sc_hd__decap_4
X_4363_ clknet_leaf_7_clk _0123_ net12 VGND VGND VPWR VPWR current_voting_frame\[2\]
+ sky130_fd_sc_hd__dfrtp_1
X_3314_ tree_instances\[1\].u_tree.pipeline_frame_id\[0\]\[0\] _0665_ _0024_ VGND
+ VGND VPWR VPWR _0946_ sky130_fd_sc_hd__mux2_1
X_4294_ _2152_ _1524_ VGND VGND VPWR VPWR _1530_ sky130_fd_sc_hd__and2_1
XFILLER_0_67_75 VGND VGND VPWR VPWR sky130_fd_sc_hd__decap_8
X_3245_ _0658_ _0906_ VGND VGND VPWR VPWR _0909_ sky130_fd_sc_hd__or2_1
XTAP_TAPCELL_ROW_1_214 VGND VPWR sky130_fd_sc_hd__tapvpwrvgnd_1
X_3176_ tree_instances\[20\].u_tree.frame_id_out\[1\] VGND VGND VPWR VPWR _0848_ sky130_fd_sc_hd__inv_2
XFILLER_0_13_3 VGND VGND VPWR VPWR sky130_fd_sc_hd__decap_8
XFILLER_0_88_192 VGND VGND VPWR VPWR sky130_fd_sc_hd__fill_1
XFILLER_0_76_365 VPWR VGND VPWR VGND sky130_ef_sc_hd__decap_12
XFILLER_0_64_527 VGND VGND VPWR VPWR sky130_fd_sc_hd__decap_4
Xclkbuf_leaf_61_clk clknet_3_1__leaf_clk VGND VGND VPWR VPWR clknet_leaf_61_clk sky130_fd_sc_hd__clkbuf_4
XFILLER_0_29_281 VGND VGND VPWR VPWR sky130_fd_sc_hd__decap_6
XFILLER_0_32_413 VGND VGND VPWR VPWR sky130_fd_sc_hd__decap_4
XANTENNA_clkbuf_3_5__f_clk_A clknet_0_clk VGND VGND VPWR VPWR sky130_fd_sc_hd__diode_2
XANTENNA__4379__RESET_B net10 VGND VGND VPWR VPWR sky130_fd_sc_hd__diode_2
XTAP_TAPCELL_ROW_9_303 VGND VPWR sky130_fd_sc_hd__tapvpwrvgnd_1
XANTENNA__3056__A1 _0702_ VGND VGND VPWR VPWR sky130_fd_sc_hd__diode_2
XFILLER_0_79_181 VPWR VGND VPWR VGND sky130_ef_sc_hd__decap_12
XTAP_TAPCELL_ROW_71_923 VGND VPWR sky130_fd_sc_hd__tapvpwrvgnd_1
XANTENNA__3056__B2 _0696_ VGND VGND VPWR VPWR sky130_fd_sc_hd__diode_2
Xclkbuf_leaf_52_clk clknet_3_5__leaf_clk VGND VGND VPWR VPWR clknet_leaf_52_clk sky130_fd_sc_hd__clkbuf_4
XTAP_TAPCELL_ROW_43_636 VGND VPWR sky130_fd_sc_hd__tapvpwrvgnd_1
XFILLER_0_55_505 VPWR VGND VPWR VGND sky130_ef_sc_hd__decap_12
XFILLER_0_12_37 VGND VGND VPWR VPWR sky130_fd_sc_hd__fill_2
XFILLER_0_35_240 VGND VGND VPWR VPWR sky130_fd_sc_hd__decap_6
XFILLER_0_88_19 VGND VGND VPWR VPWR sky130_fd_sc_hd__fill_1
XANTENNA__4308__A1 _0678_ VGND VGND VPWR VPWR sky130_fd_sc_hd__diode_2
XANTENNA__4731__RESET_B net11 VGND VGND VPWR VPWR sky130_fd_sc_hd__diode_2
XFILLER_0_50_265 VPWR VGND VPWR VGND sky130_ef_sc_hd__decap_12
Xoutput2 net2 VGND VGND VPWR VPWR frame_id_out[0] sky130_fd_sc_hd__buf_8
XFILLER_0_37_34 VGND VGND VPWR VPWR sky130_fd_sc_hd__fill_2
X_3030_ _0689_ VGND VGND VPWR VPWR _0702_ sky130_fd_sc_hd__clkbuf_4
XANTENNA__2893__B _1908_ VGND VGND VPWR VPWR sky130_fd_sc_hd__diode_2
XFILLER_0_77_107 VGND VGND VPWR VPWR sky130_fd_sc_hd__decap_4
XANTENNA__3047__A1 _0694_ VGND VGND VPWR VPWR sky130_fd_sc_hd__diode_2
XFILLER_0_53_33 VGND VGND VPWR VPWR sky130_fd_sc_hd__decap_3
Xclkbuf_leaf_43_clk clknet_3_7__leaf_clk VGND VGND VPWR VPWR clknet_leaf_43_clk sky130_fd_sc_hd__clkbuf_4
XFILLER_0_58_376 VGND VGND VPWR VPWR sky130_fd_sc_hd__fill_2
XFILLER_0_58_365 VGND VGND VPWR VPWR sky130_fd_sc_hd__fill_2
X_3932_ tree_instances\[15\].u_tree.pipeline_current_node\[0\]\[4\] VGND VGND VPWR
+ VPWR _1322_ sky130_fd_sc_hd__clkbuf_1
XFILLER_0_53_99 VGND VGND VPWR VPWR sky130_fd_sc_hd__decap_4
XFILLER_0_73_335 VGND VGND VPWR VPWR sky130_fd_sc_hd__fill_1
XANTENNA_clkbuf_leaf_9_clk_A clknet_3_2__leaf_clk VGND VGND VPWR VPWR sky130_fd_sc_hd__diode_2
X_3863_ _1275_ VGND VGND VPWR VPWR _0375_ sky130_fd_sc_hd__clkbuf_1
XFILLER_0_73_346 VPWR VGND VPWR VGND sky130_ef_sc_hd__decap_12
X_2814_ _2117_ VGND VGND VPWR VPWR _2118_ sky130_fd_sc_hd__clkbuf_1
XANTENNA__4819__RESET_B net11 VGND VGND VPWR VPWR sky130_fd_sc_hd__diode_2
XFILLER_0_14_413 VGND VGND VPWR VPWR sky130_fd_sc_hd__decap_6
XFILLER_0_5_123 VGND VGND VPWR VPWR sky130_fd_sc_hd__fill_2
XFILLER_0_26_273 VGND VGND VPWR VPWR sky130_fd_sc_hd__fill_2
X_3794_ _0594_ _1231_ VGND VGND VPWR VPWR _1240_ sky130_fd_sc_hd__and2_1
XFILLER_0_5_178 VGND VGND VPWR VPWR sky130_fd_sc_hd__decap_8
XFILLER_0_5_167 VGND VGND VPWR VPWR sky130_fd_sc_hd__fill_1
X_2745_ _1783_ VGND VGND VPWR VPWR _2056_ sky130_fd_sc_hd__clkbuf_1
XANTENNA__4472__RESET_B tree_instances\[0\].u_tree.rst_n VGND VGND VPWR VPWR sky130_fd_sc_hd__diode_2
X_2676_ _1859_ VGND VGND VPWR VPWR _1997_ sky130_fd_sc_hd__clkbuf_1
XFILLER_0_41_276 VGND VGND VPWR VPWR sky130_fd_sc_hd__decap_4
XANTENNA__4401__RESET_B net11 VGND VGND VPWR VPWR sky130_fd_sc_hd__diode_2
XFILLER_0_78_85 VGND VGND VPWR VPWR sky130_fd_sc_hd__decap_4
X_4415_ clknet_leaf_22_clk _0162_ net11 VGND VGND VPWR VPWR tree_instances\[1\].u_tree.frame_id_out\[1\]
+ sky130_fd_sc_hd__dfrtp_1
XANTENNA__3245__A _0658_ VGND VGND VPWR VPWR sky130_fd_sc_hd__diode_2
X_4346_ clknet_leaf_3_clk _0106_ tree_instances\[0\].u_tree.rst_n VGND VGND VPWR VPWR
+ net2 sky130_fd_sc_hd__dfrtp_1
XFILLER_0_94_62 VGND VGND VPWR VPWR sky130_fd_sc_hd__fill_1
X_4277_ tree_instances\[19\].u_tree.frame_id_out\[4\] tree_instances\[19\].u_tree.pipeline_frame_id\[0\]\[4\]
+ tree_instances\[19\].u_tree.tree_state\[3\] VGND VGND VPWR VPWR _1521_ sky130_fd_sc_hd__mux2_1
X_3228_ complete_votes\[3\] _0895_ VGND VGND VPWR VPWR _0897_ sky130_fd_sc_hd__or2_1
X_3159_ _0651_ tree_instances\[10\].u_tree.frame_id_out\[1\] VGND VGND VPWR VPWR _0831_
+ sky130_fd_sc_hd__xnor2_1
XFILLER_0_96_405 VPWR VGND VPWR VGND sky130_ef_sc_hd__decap_12
XFILLER_0_96_449 VPWR VGND VPWR VGND sky130_ef_sc_hd__decap_12
XANTENNA__3038__A1 _0690_ VGND VGND VPWR VPWR sky130_fd_sc_hd__diode_2
XANTENNA__3038__B2 _0696_ VGND VGND VPWR VPWR sky130_fd_sc_hd__diode_2
Xclkbuf_leaf_34_clk clknet_3_6__leaf_clk VGND VGND VPWR VPWR clknet_leaf_34_clk sky130_fd_sc_hd__clkbuf_4
XFILLER_0_64_302 VGND VGND VPWR VPWR sky130_fd_sc_hd__fill_2
XFILLER_0_37_505 VGND VGND VPWR VPWR sky130_fd_sc_hd__fill_2
XFILLER_0_91_121 VGND VGND VPWR VPWR sky130_fd_sc_hd__decap_4
XFILLER_0_37_527 VPWR VGND VPWR VGND sky130_ef_sc_hd__decap_12
XTAP_TAPCELL_ROW_40_606 VGND VPWR sky130_fd_sc_hd__tapvpwrvgnd_1
XFILLER_0_49_387 VGND VGND VPWR VPWR sky130_fd_sc_hd__decap_4
XFILLER_0_91_143 VPWR VGND VPWR VGND sky130_ef_sc_hd__decap_12
XFILLER_0_91_132 VGND VGND VPWR VPWR sky130_fd_sc_hd__decap_8
XANTENNA__4015__S _1889_ VGND VGND VPWR VPWR sky130_fd_sc_hd__diode_2
XFILLER_0_64_357 VGND VGND VPWR VPWR sky130_fd_sc_hd__fill_2
XFILLER_0_32_232 VGND VGND VPWR VPWR sky130_fd_sc_hd__fill_2
XFILLER_0_2_3 VPWR VGND VPWR VGND sky130_ef_sc_hd__decap_12
XFILLER_0_87_449 VPWR VGND VPWR VGND sky130_ef_sc_hd__decap_12
XTAP_TAPCELL_ROW_56_772 VGND VPWR sky130_fd_sc_hd__tapvpwrvgnd_1
Xclkbuf_leaf_25_clk clknet_3_6__leaf_clk VGND VGND VPWR VPWR clknet_leaf_25_clk sky130_fd_sc_hd__clkbuf_4
XTAP_TAPCELL_ROW_28_485 VGND VPWR sky130_fd_sc_hd__tapvpwrvgnd_1
XFILLER_0_28_516 VGND VGND VPWR VPWR sky130_fd_sc_hd__fill_2
XFILLER_0_55_313 VGND VGND VPWR VPWR sky130_fd_sc_hd__fill_2
XFILLER_0_70_338 VGND VGND VPWR VPWR sky130_fd_sc_hd__fill_2
X_2530_ tree_instances\[3\].u_tree.tree_state\[0\] _1871_ _1872_ VGND VGND VPWR VPWR
+ _0069_ sky130_fd_sc_hd__a21o_1
XTAP_TAPCELL_ROW_93_1137 VGND VPWR sky130_fd_sc_hd__tapvpwrvgnd_1
X_2461_ _1810_ _1811_ VGND VGND VPWR VPWR _1812_ sky130_fd_sc_hd__nand2_1
XFILLER_0_2_159 VGND VGND VPWR VPWR sky130_fd_sc_hd__fill_2
X_4200_ _1481_ VGND VGND VPWR VPWR _0506_ sky130_fd_sc_hd__clkbuf_1
XANTENNA__3065__A _0661_ VGND VGND VPWR VPWR sky130_fd_sc_hd__diode_2
X_2392_ _1575_ tree_instances\[6\].u_tree.pipeline_valid\[0\] VGND VGND VPWR VPWR
+ _1751_ sky130_fd_sc_hd__or2_1
X_4131_ tree_instances\[20\].u_tree.tree_state\[0\] _1907_ VGND VGND VPWR VPWR _1437_
+ sky130_fd_sc_hd__nand2_1
XFILLER_0_48_88 VGND VGND VPWR VPWR sky130_fd_sc_hd__fill_2
X_4062_ tree_instances\[15\].u_tree.frame_id_out\[2\] tree_instances\[15\].u_tree.pipeline_frame_id\[0\]\[2\]
+ _1936_ VGND VGND VPWR VPWR _1393_ sky130_fd_sc_hd__mux2_1
XFILLER_0_3_57 VPWR VGND VPWR VGND sky130_ef_sc_hd__decap_12
X_3013_ _0684_ VGND VGND VPWR VPWR _0685_ sky130_fd_sc_hd__buf_2
XFILLER_0_78_427 VGND VGND VPWR VPWR sky130_fd_sc_hd__fill_2
XFILLER_0_78_405 VGND VGND VPWR VPWR sky130_fd_sc_hd__decap_6
Xclkbuf_leaf_16_clk clknet_3_2__leaf_clk VGND VGND VPWR VPWR clknet_leaf_16_clk sky130_fd_sc_hd__clkbuf_4
XFILLER_0_80_64 VGND VGND VPWR VPWR sky130_fd_sc_hd__fill_2
X_3915_ tree_instances\[12\].u_tree.frame_id_out\[1\] tree_instances\[12\].u_tree.pipeline_frame_id\[0\]\[1\]
+ _1579_ VGND VGND VPWR VPWR _1310_ sky130_fd_sc_hd__mux2_1
XFILLER_0_73_110 VGND VGND VPWR VPWR sky130_fd_sc_hd__fill_2
X_4895_ clknet_leaf_44_clk _0097_ net12 VGND VGND VPWR VPWR tree_instances\[20\].u_tree.prediction_valid
+ sky130_fd_sc_hd__dfrtp_1
XFILLER_0_6_421 VPWR VGND VPWR VGND sky130_ef_sc_hd__decap_12
XANTENNA__4653__RESET_B tree_instances\[0\].u_tree.rst_n VGND VGND VPWR VPWR sky130_fd_sc_hd__diode_2
X_3846_ tree_instances\[11\].u_tree.pipeline_frame_id\[0\]\[1\] _1124_ _0006_ VGND
+ VGND VPWR VPWR _1267_ sky130_fd_sc_hd__mux2_1
XFILLER_0_80_3 VGND VGND VPWR VPWR sky130_fd_sc_hd__fill_2
XFILLER_0_14_221 VGND VGND VPWR VPWR sky130_fd_sc_hd__fill_2
X_3777_ _1649_ _1230_ _0042_ tree_instances\[9\].u_tree.pipeline_valid\[0\] VGND VGND
+ VPWR VPWR _0334_ sky130_fd_sc_hd__o2bb2a_1
X_2728_ _1685_ tree_instances\[7\].u_tree.prediction_valid VGND VGND VPWR VPWR _0103_
+ sky130_fd_sc_hd__nor2_1
X_2659_ _1978_ VGND VGND VPWR VPWR _1981_ sky130_fd_sc_hd__clkbuf_1
XFILLER_0_1_181 VGND VGND VPWR VPWR sky130_fd_sc_hd__decap_3
X_4329_ clknet_leaf_1_clk _0050_ net9 VGND VGND VPWR VPWR tree_instances\[13\].u_tree.tree_state\[0\]
+ sky130_fd_sc_hd__dfstp_1
XFILLER_0_69_405 VGND VGND VPWR VPWR sky130_fd_sc_hd__fill_2
XANTENNA__2319__A _1575_ VGND VGND VPWR VPWR sky130_fd_sc_hd__diode_2
XFILLER_0_69_449 VGND VGND VPWR VPWR sky130_fd_sc_hd__fill_2
XFILLER_0_84_419 VGND VGND VPWR VPWR sky130_fd_sc_hd__fill_1
XFILLER_0_49_140 VGND VGND VPWR VPWR sky130_fd_sc_hd__fill_2
XTAP_TAPCELL_ROW_53_742 VGND VPWR sky130_fd_sc_hd__tapvpwrvgnd_1
XTAP_TAPCELL_ROW_25_455 VGND VPWR sky130_fd_sc_hd__tapvpwrvgnd_1
XFILLER_0_37_346 VPWR VGND VPWR VGND sky130_ef_sc_hd__decap_12
XFILLER_0_92_474 VGND VGND VPWR VPWR sky130_fd_sc_hd__fill_2
XANTENNA__4394__RESET_B net13 VGND VGND VPWR VPWR sky130_fd_sc_hd__diode_2
XFILLER_0_52_349 VGND VGND VPWR VPWR sky130_fd_sc_hd__decap_8
XFILLER_0_20_257 VGND VGND VPWR VPWR sky130_fd_sc_hd__fill_1
XFILLER_0_87_202 VGND VGND VPWR VPWR sky130_fd_sc_hd__fill_2
XFILLER_0_68_482 VGND VGND VPWR VPWR sky130_fd_sc_hd__fill_2
XFILLER_0_68_460 VGND VGND VPWR VPWR sky130_fd_sc_hd__decap_6
XFILLER_0_28_302 VGND VGND VPWR VPWR sky130_fd_sc_hd__decap_6
XFILLER_0_55_110 VGND VGND VPWR VPWR sky130_fd_sc_hd__fill_2
XFILLER_0_83_441 VGND VGND VPWR VPWR sky130_fd_sc_hd__decap_6
X_3700_ tree_instances\[8\].u_tree.pipeline_current_node\[0\]\[7\] _1178_ VGND VGND
+ VPWR VPWR _1187_ sky130_fd_sc_hd__and2_1
XFILLER_0_7_218 VGND VGND VPWR VPWR sky130_fd_sc_hd__decap_6
XANTENNA__3422__A1 _0925_ VGND VGND VPWR VPWR sky130_fd_sc_hd__diode_2
XFILLER_0_50_23 VGND VGND VPWR VPWR sky130_fd_sc_hd__fill_1
X_4680_ clknet_leaf_17_clk _0384_ net11 VGND VGND VPWR VPWR tree_instances\[12\].u_tree.pipeline_current_node\[0\]\[6\]
+ sky130_fd_sc_hd__dfrtp_1
XFILLER_0_83_485 VPWR VGND VPWR VGND sky130_ef_sc_hd__decap_12
XFILLER_0_55_165 VGND VGND VPWR VPWR sky130_fd_sc_hd__decap_3
X_3631_ _1143_ VGND VGND VPWR VPWR _0275_ sky130_fd_sc_hd__clkbuf_1
XFILLER_0_55_198 VGND VGND VPWR VPWR sky130_fd_sc_hd__decap_3
X_3562_ _1094_ _1096_ VGND VGND VPWR VPWR _1097_ sky130_fd_sc_hd__and2_1
X_2513_ _1857_ VGND VGND VPWR VPWR _1858_ sky130_fd_sc_hd__clkbuf_1
X_3493_ _1579_ _1050_ _0008_ tree_instances\[12\].u_tree.pipeline_valid\[0\] VGND
+ VGND VPWR VPWR _0230_ sky130_fd_sc_hd__o2bb2a_1
Xclkbuf_leaf_5_clk clknet_3_0__leaf_clk VGND VGND VPWR VPWR clknet_leaf_5_clk sky130_fd_sc_hd__clkbuf_4
X_2444_ _1795_ _1796_ VGND VGND VPWR VPWR _1797_ sky130_fd_sc_hd__nor2_1
X_2375_ tree_instances\[14\].u_tree.pipeline_current_node\[0\]\[6\] VGND VGND VPWR
+ VPWR _1736_ sky130_fd_sc_hd__clkbuf_1
X_4114_ tree_instances\[18\].u_tree.pipeline_current_node\[0\]\[2\] VGND VGND VPWR
+ VPWR _1420_ sky130_fd_sc_hd__clkbuf_1
XFILLER_0_75_75 VPWR VGND VPWR VGND sky130_ef_sc_hd__decap_12
X_4045_ _1384_ VGND VGND VPWR VPWR _0448_ sky130_fd_sc_hd__clkbuf_1
XFILLER_0_91_30 VGND VGND VPWR VPWR sky130_fd_sc_hd__fill_2
XTAP_TAPCELL_ROW_67_878 VGND VPWR sky130_fd_sc_hd__tapvpwrvgnd_1
XFILLER_0_78_268 VGND VGND VPWR VPWR sky130_fd_sc_hd__fill_2
XFILLER_0_78_246 VGND VGND VPWR VPWR sky130_fd_sc_hd__decap_4
XFILLER_0_93_238 VGND VGND VPWR VPWR sky130_fd_sc_hd__decap_8
XANTENNA__4834__RESET_B net10 VGND VGND VPWR VPWR sky130_fd_sc_hd__diode_2
XFILLER_0_86_290 VPWR VGND VPWR VGND sky130_ef_sc_hd__decap_12
XFILLER_0_74_452 VGND VGND VPWR VPWR sky130_fd_sc_hd__fill_1
XFILLER_0_74_430 VGND VGND VPWR VPWR sky130_fd_sc_hd__fill_2
XFILLER_0_19_335 VGND VGND VPWR VPWR sky130_fd_sc_hd__fill_1
XFILLER_0_19_357 VGND VGND VPWR VPWR sky130_fd_sc_hd__fill_2
XTAP_TAPCELL_ROW_22_425 VGND VPWR sky130_fd_sc_hd__tapvpwrvgnd_1
XTAP_TAPCELL_ROW_50_712 VGND VPWR sky130_fd_sc_hd__tapvpwrvgnd_1
X_4878_ clknet_leaf_38_clk _0550_ net10 VGND VGND VPWR VPWR tree_instances\[20\].u_tree.pipeline_current_node\[0\]\[3\]
+ sky130_fd_sc_hd__dfrtp_1
XFILLER_0_34_305 VGND VGND VPWR VPWR sky130_fd_sc_hd__decap_3
X_3829_ _2036_ _1255_ VGND VGND VPWR VPWR _1258_ sky130_fd_sc_hd__and2_1
XANTENNA__2602__A _1575_ VGND VGND VPWR VPWR sky130_fd_sc_hd__diode_2
XFILLER_0_6_295 VGND VGND VPWR VPWR sky130_fd_sc_hd__fill_1
XFILLER_0_15_541 VPWR VGND VPWR VGND sky130_ef_sc_hd__decap_12
XFILLER_0_30_511 VPWR VGND VPWR VGND sky130_ef_sc_hd__decap_12
XFILLER_0_30_533 VGND VGND VPWR VPWR sky130_fd_sc_hd__decap_4
XFILLER_0_42_393 VGND VGND VPWR VPWR sky130_fd_sc_hd__decap_3
XANTENNA__2991__B _1552_ VGND VGND VPWR VPWR sky130_fd_sc_hd__diode_2
XTAP_TAPCELL_ROW_38_591 VGND VPWR sky130_fd_sc_hd__tapvpwrvgnd_1
XANTENNA__4575__RESET_B net12 VGND VGND VPWR VPWR sky130_fd_sc_hd__diode_2
XFILLER_0_69_279 VGND VGND VPWR VPWR sky130_fd_sc_hd__fill_1
XANTENNA_clkbuf_leaf_34_clk_A clknet_3_6__leaf_clk VGND VGND VPWR VPWR sky130_fd_sc_hd__diode_2
XFILLER_0_77_290 VGND VGND VPWR VPWR sky130_fd_sc_hd__decap_4
XANTENNA__4504__RESET_B net13 VGND VGND VPWR VPWR sky130_fd_sc_hd__diode_2
XFILLER_0_25_305 VPWR VGND VPWR VGND sky130_ef_sc_hd__decap_12
XFILLER_0_20_15 VPWR VGND VPWR VGND sky130_ef_sc_hd__decap_12
XFILLER_0_80_477 VGND VGND VPWR VPWR sky130_fd_sc_hd__fill_2
XANTENNA_clkbuf_leaf_49_clk_A clknet_3_5__leaf_clk VGND VGND VPWR VPWR sky130_fd_sc_hd__diode_2
XFILLER_0_52_157 VGND VGND VPWR VPWR sky130_fd_sc_hd__fill_2
XFILLER_0_0_405 VPWR VGND VPWR VGND sky130_ef_sc_hd__decap_12
XTAP_TAPCELL_ROW_90_1107 VGND VPWR sky130_fd_sc_hd__tapvpwrvgnd_1
XFILLER_0_0_449 VPWR VGND VPWR VGND sky130_ef_sc_hd__decap_12
XFILLER_0_88_555 VPWR VGND VPWR VGND sky130_ef_sc_hd__decap_12
XTAP_TAPCELL_ROW_64_848 VGND VPWR sky130_fd_sc_hd__tapvpwrvgnd_1
XFILLER_0_48_419 VGND VGND VPWR VPWR sky130_fd_sc_hd__fill_1
X_2993_ _0665_ _0669_ VGND VGND VPWR VPWR _0670_ sky130_fd_sc_hd__nor2_1
XFILLER_0_61_55 VGND VGND VPWR VPWR sky130_fd_sc_hd__fill_1
XFILLER_0_0_69 VPWR VGND VPWR VGND sky130_ef_sc_hd__decap_12
X_4801_ clknet_leaf_54_clk _0488_ net13 VGND VGND VPWR VPWR tree_instances\[17\].u_tree.pipeline_current_node\[0\]\[5\]
+ sky130_fd_sc_hd__dfrtp_1
XFILLER_0_71_400 VGND VGND VPWR VPWR sky130_fd_sc_hd__decap_3
X_4732_ clknet_leaf_27_clk _0430_ net11 VGND VGND VPWR VPWR tree_instances\[14\].u_tree.pipeline_frame_id\[0\]\[1\]
+ sky130_fd_sc_hd__dfrtp_1
XFILLER_0_28_165 VPWR VGND VPWR VGND sky130_ef_sc_hd__decap_12
XFILLER_0_56_474 VGND VGND VPWR VPWR sky130_fd_sc_hd__fill_2
X_4663_ clknet_leaf_9_clk _0368_ net12 VGND VGND VPWR VPWR tree_instances\[11\].u_tree.pipeline_frame_id\[0\]\[2\]
+ sky130_fd_sc_hd__dfrtp_1
XFILLER_0_43_113 VGND VGND VPWR VPWR sky130_fd_sc_hd__fill_2
XFILLER_0_56_485 VGND VGND VPWR VPWR sky130_fd_sc_hd__fill_2
X_3614_ tree_instances\[6\].u_tree.frame_id_out\[3\] tree_instances\[6\].u_tree.pipeline_frame_id\[0\]\[3\]
+ _1750_ VGND VGND VPWR VPWR _1132_ sky130_fd_sc_hd__mux2_1
X_4594_ clknet_leaf_8_clk _0104_ net12 VGND VGND VPWR VPWR tree_instances\[8\].u_tree.prediction_valid
+ sky130_fd_sc_hd__dfrtp_1
XFILLER_0_12_522 VGND VGND VPWR VPWR sky130_fd_sc_hd__decap_8
XFILLER_0_9_89 VGND VGND VPWR VPWR sky130_fd_sc_hd__decap_3
XFILLER_0_31_319 VGND VGND VPWR VPWR sky130_fd_sc_hd__decap_8
XFILLER_0_12_533 VPWR VGND VPWR VGND sky130_ef_sc_hd__decap_12
X_3545_ tree_instances\[5\].u_tree.frame_id_out\[2\] tree_instances\[5\].u_tree.pipeline_frame_id\[0\]\[2\]
+ _1770_ VGND VGND VPWR VPWR _1086_ sky130_fd_sc_hd__mux2_1
X_3476_ tree_instances\[4\].u_tree.pipeline_frame_id\[0\]\[3\] _0925_ _0032_ VGND
+ VGND VPWR VPWR _1042_ sky130_fd_sc_hd__mux2_1
X_2427_ _1778_ _1780_ VGND VGND VPWR VPWR _1781_ sky130_fd_sc_hd__nor2_1
XFILLER_0_43_3 VPWR VGND VPWR VGND sky130_ef_sc_hd__decap_12
X_2358_ _1720_ VGND VGND VPWR VPWR _1721_ sky130_fd_sc_hd__inv_2
X_2289_ tree_instances\[8\].u_tree.pipeline_current_node\[0\]\[2\] VGND VGND VPWR
+ VPWR _1660_ sky130_fd_sc_hd__clkbuf_1
XFILLER_0_79_511 VGND VGND VPWR VPWR sky130_fd_sc_hd__fill_1
X_4028_ tree_instances\[15\].u_tree.tree_state\[1\] tree_instances\[15\].u_tree.tree_state\[2\]
+ _0642_ VGND VGND VPWR VPWR _1375_ sky130_fd_sc_hd__or3_1
XFILLER_0_94_525 VGND VGND VPWR VPWR sky130_fd_sc_hd__decap_6
XFILLER_0_94_569 VGND VGND VPWR VPWR sky130_fd_sc_hd__decap_4
XTAP_TAPCELL_ROW_35_561 VGND VPWR sky130_fd_sc_hd__tapvpwrvgnd_1
XFILLER_0_47_430 VGND VGND VPWR VPWR sky130_fd_sc_hd__fill_2
XFILLER_0_74_293 VPWR VGND VPWR VGND sky130_ef_sc_hd__decap_12
XFILLER_0_62_411 VGND VGND VPWR VPWR sky130_fd_sc_hd__fill_2
XFILLER_0_62_477 VPWR VGND VPWR VGND sky130_ef_sc_hd__decap_12
XFILLER_0_62_466 VGND VGND VPWR VPWR sky130_fd_sc_hd__decap_4
XFILLER_0_34_168 VPWR VGND VPWR VGND sky130_ef_sc_hd__decap_12
XFILLER_0_15_393 VPWR VGND VPWR VGND sky130_ef_sc_hd__decap_12
XTAP_TAPCELL_ROW_7_275 VGND VPWR sky130_fd_sc_hd__tapvpwrvgnd_1
XANTENNA__4756__RESET_B net13 VGND VGND VPWR VPWR sky130_fd_sc_hd__diode_2
XTAP_TAPCELL_ROW_87_1080 VGND VPWR sky130_fd_sc_hd__tapvpwrvgnd_1
XFILLER_0_15_15 VGND VGND VPWR VPWR sky130_fd_sc_hd__decap_4
XTAP_TAPCELL_ROW_61_818 VGND VPWR sky130_fd_sc_hd__tapvpwrvgnd_1
XFILLER_0_65_260 VPWR VGND VPWR VGND sky130_ef_sc_hd__decap_12
XFILLER_0_31_25 VGND VGND VPWR VPWR sky130_fd_sc_hd__fill_1
XFILLER_0_38_452 VGND VGND VPWR VPWR sky130_fd_sc_hd__decap_4
XFILLER_0_25_113 VGND VGND VPWR VPWR sky130_fd_sc_hd__fill_2
XFILLER_0_38_485 VGND VGND VPWR VPWR sky130_fd_sc_hd__fill_2
XANTENNA__4050__A1 _0672_ VGND VGND VPWR VPWR sky130_fd_sc_hd__diode_2
XFILLER_0_25_135 VGND VGND VPWR VPWR sky130_fd_sc_hd__fill_2
XFILLER_0_53_455 VGND VGND VPWR VPWR sky130_fd_sc_hd__fill_1
XFILLER_0_21_330 VGND VGND VPWR VPWR sky130_fd_sc_hd__fill_2
X_3330_ tree_instances\[1\].u_tree.frame_id_out\[3\] tree_instances\[1\].u_tree.pipeline_frame_id\[0\]\[3\]
+ tree_instances\[1\].u_tree.tree_state\[3\] VGND VGND VPWR VPWR _0954_ sky130_fd_sc_hd__mux2_1
XFILLER_0_21_363 VGND VGND VPWR VPWR sky130_fd_sc_hd__fill_1
XFILLER_0_21_374 VGND VGND VPWR VPWR sky130_fd_sc_hd__fill_2
X_3261_ _2135_ _0912_ VGND VGND VPWR VPWR _0918_ sky130_fd_sc_hd__and2_1
XFILLER_0_56_11 VGND VGND VPWR VPWR sky130_fd_sc_hd__fill_2
X_2212_ _1582_ _1586_ _1588_ _1591_ VGND VGND VPWR VPWR _1592_ sky130_fd_sc_hd__and4_1
X_3192_ _0696_ tree_instances\[13\].u_tree.frame_id_out\[4\] _0863_ VGND VGND VPWR
+ VPWR _0864_ sky130_fd_sc_hd__a21oi_1
XFILLER_0_56_77 VGND VGND VPWR VPWR sky130_fd_sc_hd__decap_6
XANTENNA__4497__RESET_B tree_instances\[0\].u_tree.rst_n VGND VGND VPWR VPWR sky130_fd_sc_hd__diode_2
XANTENNA__4426__RESET_B tree_instances\[0\].u_tree.rst_n VGND VGND VPWR VPWR sky130_fd_sc_hd__diode_2
XTAP_TAPCELL_ROW_49_697 VGND VPWR sky130_fd_sc_hd__tapvpwrvgnd_1
XFILLER_0_88_374 VGND VGND VPWR VPWR sky130_fd_sc_hd__fill_2
XFILLER_0_76_503 VPWR VGND VPWR VGND sky130_ef_sc_hd__decap_12
XTAP_TAPCELL_ROW_32_531 VGND VPWR sky130_fd_sc_hd__tapvpwrvgnd_1
X_2976_ _0655_ net4 _0645_ VGND VGND VPWR VPWR _0656_ sky130_fd_sc_hd__mux2_1
XFILLER_0_8_368 VGND VGND VPWR VPWR sky130_fd_sc_hd__fill_2
XFILLER_0_16_102 VGND VGND VPWR VPWR sky130_fd_sc_hd__decap_4
X_4715_ clknet_leaf_2_clk _0418_ net9 VGND VGND VPWR VPWR tree_instances\[13\].u_tree.ready_for_next
+ sky130_fd_sc_hd__dfstp_1
XANTENNA__3248__A _0662_ VGND VGND VPWR VPWR sky130_fd_sc_hd__diode_2
X_4646_ clknet_leaf_64_clk _0069_ net9 VGND VGND VPWR VPWR tree_instances\[3\].u_tree.tree_state\[0\]
+ sky130_fd_sc_hd__dfstp_1
XFILLER_0_44_477 VPWR VGND VPWR VGND sky130_ef_sc_hd__decap_12
X_4577_ clknet_leaf_16_clk _0297_ net11 VGND VGND VPWR VPWR tree_instances\[8\].u_tree.pipeline_current_node\[0\]\[3\]
+ sky130_fd_sc_hd__dfrtp_1
XANTENNA_wire1_A clk VGND VGND VPWR VPWR sky130_fd_sc_hd__diode_2
XFILLER_0_12_363 VGND VGND VPWR VPWR sky130_fd_sc_hd__fill_1
X_3528_ _1077_ VGND VGND VPWR VPWR _0238_ sky130_fd_sc_hd__clkbuf_1
X_3459_ _1033_ VGND VGND VPWR VPWR _0213_ sky130_fd_sc_hd__clkbuf_1
XTAP_TAPCELL_ROW_4_245 VGND VPWR sky130_fd_sc_hd__tapvpwrvgnd_1
XFILLER_0_79_330 VGND VGND VPWR VPWR sky130_fd_sc_hd__decap_3
XFILLER_0_67_558 VGND VGND VPWR VPWR sky130_fd_sc_hd__fill_2
XFILLER_0_35_444 VGND VGND VPWR VPWR sky130_fd_sc_hd__decap_4
XFILLER_0_90_572 VGND VGND VPWR VPWR sky130_fd_sc_hd__fill_2
XFILLER_0_22_105 VGND VGND VPWR VPWR sky130_fd_sc_hd__fill_2
XFILLER_0_50_414 VGND VGND VPWR VPWR sky130_fd_sc_hd__decap_6
XANTENNA__2997__A _0672_ VGND VGND VPWR VPWR sky130_fd_sc_hd__diode_2
XANTENNA__3846__A1 _1124_ VGND VGND VPWR VPWR sky130_fd_sc_hd__diode_2
XANTENNA__4590__RESET_B net11 VGND VGND VPWR VPWR sky130_fd_sc_hd__diode_2
XTAP_TAPCELL_ROW_46_667 VGND VPWR sky130_fd_sc_hd__tapvpwrvgnd_1
X_2830_ _1642_ VGND VGND VPWR VPWR _2133_ sky130_fd_sc_hd__clkbuf_1
XFILLER_0_42_46 VGND VGND VPWR VPWR sky130_fd_sc_hd__fill_2
XFILLER_0_26_433 VPWR VGND VPWR VGND sky130_ef_sc_hd__decap_12
X_2761_ tree_instances\[13\].u_tree.prediction_valid _1577_ VGND VGND VPWR VPWR _2070_
+ sky130_fd_sc_hd__and2b_1
X_2692_ _2010_ VGND VGND VPWR VPWR _2011_ sky130_fd_sc_hd__clkbuf_1
XFILLER_0_81_561 VPWR VGND VPWR VGND sky130_ef_sc_hd__decap_12
X_4500_ clknet_leaf_53_clk _0231_ net13 VGND VGND VPWR VPWR tree_instances\[5\].u_tree.pipeline_current_node\[0\]\[0\]
+ sky130_fd_sc_hd__dfrtp_1
XFILLER_0_26_477 VGND VGND VPWR VPWR sky130_fd_sc_hd__fill_2
XFILLER_0_41_425 VPWR VGND VPWR VGND sky130_ef_sc_hd__decap_12
XTAP_TAPCELL_ROW_96_1168 VGND VPWR sky130_fd_sc_hd__tapvpwrvgnd_1
X_4431_ clknet_leaf_57_clk _0177_ net13 VGND VGND VPWR VPWR tree_instances\[2\].u_tree.pipeline_frame_id\[0\]\[0\]
+ sky130_fd_sc_hd__dfrtp_1
XFILLER_0_41_458 VGND VGND VPWR VPWR sky130_fd_sc_hd__decap_4
XTAP_TAPCELL_ROW_96_1179 VGND VPWR sky130_fd_sc_hd__tapvpwrvgnd_1
X_4362_ clknet_leaf_7_clk _0122_ net12 VGND VGND VPWR VPWR current_voting_frame\[1\]
+ sky130_fd_sc_hd__dfrtp_1
X_3313_ _0945_ VGND VGND VPWR VPWR _0155_ sky130_fd_sc_hd__clkbuf_1
XANTENNA__4678__RESET_B net12 VGND VGND VPWR VPWR sky130_fd_sc_hd__diode_2
X_4293_ _1529_ VGND VGND VPWR VPWR _0551_ sky130_fd_sc_hd__clkbuf_1
X_3244_ _0658_ _0906_ VGND VGND VPWR VPWR _0908_ sky130_fd_sc_hd__nand2_1
XANTENNA__4607__RESET_B net9 VGND VGND VPWR VPWR sky130_fd_sc_hd__diode_2
XFILLER_0_83_53 VGND VGND VPWR VPWR sky130_fd_sc_hd__decap_3
XTAP_TAPCELL_ROW_1_215 VGND VPWR sky130_fd_sc_hd__tapvpwrvgnd_1
X_3175_ _0704_ tree_instances\[20\].u_tree.frame_id_out\[2\] tree_instances\[20\].u_tree.frame_id_out\[3\]
+ _0690_ _0846_ VGND VGND VPWR VPWR _0847_ sky130_fd_sc_hd__a221oi_1
XFILLER_0_95_119 VPWR VGND VPWR VGND sky130_ef_sc_hd__decap_12
XFILLER_0_49_558 VGND VGND VPWR VPWR sky130_fd_sc_hd__fill_2
XTAP_TAPCELL_ROW_17_380 VGND VPWR sky130_fd_sc_hd__tapvpwrvgnd_1
XFILLER_0_49_569 VGND VGND VPWR VPWR sky130_fd_sc_hd__decap_4
XFILLER_0_91_325 VGND VGND VPWR VPWR sky130_fd_sc_hd__fill_2
XFILLER_0_17_422 VGND VGND VPWR VPWR sky130_fd_sc_hd__decap_4
XFILLER_0_29_271 VGND VGND VPWR VPWR sky130_fd_sc_hd__fill_2
X_2959_ _0642_ VGND VGND VPWR VPWR _0014_ sky130_fd_sc_hd__inv_2
XFILLER_0_72_572 VGND VGND VPWR VPWR sky130_fd_sc_hd__fill_2
XFILLER_0_44_274 VGND VGND VPWR VPWR sky130_fd_sc_hd__decap_8
X_4629_ clknet_leaf_2_clk _0339_ net9 VGND VGND VPWR VPWR tree_instances\[10\].u_tree.pipeline_current_node\[0\]\[4\]
+ sky130_fd_sc_hd__dfrtp_1
XANTENNA__4348__RESET_B net12 VGND VGND VPWR VPWR sky130_fd_sc_hd__diode_2
XTAP_TAPCELL_ROW_84_1050 VGND VPWR sky130_fd_sc_hd__tapvpwrvgnd_1
XFILLER_0_79_193 VGND VGND VPWR VPWR sky130_fd_sc_hd__decap_8
XFILLER_0_82_303 VGND VGND VPWR VPWR sky130_fd_sc_hd__decap_4
XTAP_TAPCELL_ROW_43_637 VGND VPWR sky130_fd_sc_hd__tapvpwrvgnd_1
XANTENNA__4005__A1 _1162_ VGND VGND VPWR VPWR sky130_fd_sc_hd__diode_2
XFILLER_0_55_539 VGND VGND VPWR VPWR sky130_fd_sc_hd__fill_1
XFILLER_0_63_550 VGND VGND VPWR VPWR sky130_fd_sc_hd__fill_2
XFILLER_0_63_572 VGND VGND VPWR VPWR sky130_fd_sc_hd__fill_2
XFILLER_0_23_469 VPWR VGND VPWR VGND sky130_ef_sc_hd__decap_12
Xoutput3 net3 VGND VGND VPWR VPWR frame_id_out[1] sky130_fd_sc_hd__buf_8
XFILLER_0_50_277 VGND VGND VPWR VPWR sky130_fd_sc_hd__decap_8
XANTENNA__4771__RESET_B net10 VGND VGND VPWR VPWR sky130_fd_sc_hd__diode_2
XANTENNA__4700__RESET_B net9 VGND VGND VPWR VPWR sky130_fd_sc_hd__diode_2
X_3931_ _1314_ VGND VGND VPWR VPWR _1321_ sky130_fd_sc_hd__clkbuf_1
XFILLER_0_73_325 VGND VGND VPWR VPWR sky130_fd_sc_hd__fill_1
X_3862_ tree_instances\[11\].u_tree.frame_id_out\[4\] tree_instances\[11\].u_tree.pipeline_frame_id\[0\]\[4\]
+ tree_instances\[11\].u_tree.tree_state\[3\] VGND VGND VPWR VPWR _1275_ sky130_fd_sc_hd__mux2_1
XFILLER_0_73_358 VPWR VGND VPWR VGND sky130_ef_sc_hd__decap_12
XTAP_TAPCELL_ROW_14_350 VGND VPWR sky130_fd_sc_hd__tapvpwrvgnd_1
X_2813_ _2116_ VGND VGND VPWR VPWR _2117_ sky130_fd_sc_hd__clkbuf_1
XFILLER_0_5_113 VGND VGND VPWR VPWR sky130_fd_sc_hd__fill_2
X_3793_ _1239_ VGND VGND VPWR VPWR _0341_ sky130_fd_sc_hd__clkbuf_1
X_2744_ _2054_ VGND VGND VPWR VPWR _2055_ sky130_fd_sc_hd__clkbuf_1
XFILLER_0_41_211 VPWR VGND VPWR VGND sky130_ef_sc_hd__decap_12
XANTENNA__4859__RESET_B net13 VGND VGND VPWR VPWR sky130_fd_sc_hd__diode_2
XFILLER_0_14_469 VGND VGND VPWR VPWR sky130_fd_sc_hd__decap_6
X_2675_ _1995_ VGND VGND VPWR VPWR _1996_ sky130_fd_sc_hd__clkbuf_1
XFILLER_0_41_266 VGND VGND VPWR VPWR sky130_fd_sc_hd__fill_1
X_4414_ clknet_leaf_21_clk _0161_ net11 VGND VGND VPWR VPWR tree_instances\[1\].u_tree.frame_id_out\[0\]
+ sky130_fd_sc_hd__dfrtp_1
X_4345_ clknet_leaf_70_clk _0000_ tree_instances\[0\].u_tree.rst_n VGND VGND VPWR
+ VPWR net7 sky130_fd_sc_hd__dfrtp_1
X_4276_ _1520_ VGND VGND VPWR VPWR _0543_ sky130_fd_sc_hd__clkbuf_1
X_3227_ complete_votes\[3\] _0895_ VGND VGND VPWR VPWR _0896_ sky130_fd_sc_hd__nand2_1
X_3158_ _0654_ _0826_ tree_instances\[10\].u_tree.frame_id_out\[3\] _0702_ VGND VGND
+ VPWR VPWR _0830_ sky130_fd_sc_hd__a22o_1
XFILLER_0_96_417 VGND VGND VPWR VPWR sky130_fd_sc_hd__decap_3
XFILLER_0_89_480 VGND VGND VPWR VPWR sky130_fd_sc_hd__fill_1
X_3089_ _0646_ tree_instances\[18\].u_tree.frame_id_out\[0\] _0757_ _0657_ VGND VGND
+ VPWR VPWR _0761_ sky130_fd_sc_hd__o2bb2a_1
XFILLER_0_76_141 VGND VGND VPWR VPWR sky130_fd_sc_hd__fill_2
XFILLER_0_91_111 VGND VGND VPWR VPWR sky130_fd_sc_hd__fill_1
XFILLER_0_9_452 VGND VGND VPWR VPWR sky130_fd_sc_hd__decap_8
XFILLER_0_37_517 VGND VGND VPWR VPWR sky130_fd_sc_hd__fill_2
XFILLER_0_37_539 VGND VGND VPWR VPWR sky130_fd_sc_hd__decap_8
XTAP_TAPCELL_ROW_40_607 VGND VPWR sky130_fd_sc_hd__tapvpwrvgnd_1
XANTENNA__2605__A _1666_ VGND VGND VPWR VPWR sky130_fd_sc_hd__diode_2
XFILLER_0_9_485 VPWR VGND VPWR VGND sky130_ef_sc_hd__decap_12
XFILLER_0_91_155 VPWR VGND VPWR VGND sky130_ef_sc_hd__decap_12
XFILLER_0_45_550 VGND VGND VPWR VPWR sky130_fd_sc_hd__fill_2
XFILLER_0_45_572 VGND VGND VPWR VPWR sky130_fd_sc_hd__fill_2
XANTENNA__4693__SET_B net11 VGND VGND VPWR VPWR sky130_fd_sc_hd__diode_2
XFILLER_0_60_520 VPWR VGND VPWR VGND sky130_ef_sc_hd__decap_12
XFILLER_0_20_417 VGND VGND VPWR VPWR sky130_fd_sc_hd__decap_3
XFILLER_0_32_277 VGND VGND VPWR VPWR sky130_fd_sc_hd__fill_2
XFILLER_0_32_299 VGND VGND VPWR VPWR sky130_fd_sc_hd__fill_2
XANTENNA__4529__RESET_B net11 VGND VGND VPWR VPWR sky130_fd_sc_hd__diode_2
XTAP_TAPCELL_ROW_56_773 VGND VPWR sky130_fd_sc_hd__tapvpwrvgnd_1
XFILLER_0_95_461 VPWR VGND VPWR VGND sky130_ef_sc_hd__decap_12
XTAP_TAPCELL_ROW_28_486 VGND VPWR sky130_fd_sc_hd__tapvpwrvgnd_1
XFILLER_0_43_509 VPWR VGND VPWR VGND sky130_ef_sc_hd__decap_12
XFILLER_0_55_358 VGND VGND VPWR VPWR sky130_fd_sc_hd__fill_1
XTAP_TAPCELL_ROW_11_320 VGND VPWR sky130_fd_sc_hd__tapvpwrvgnd_1
XFILLER_0_63_391 VGND VGND VPWR VPWR sky130_fd_sc_hd__fill_1
XFILLER_0_2_105 VGND VGND VPWR VPWR sky130_fd_sc_hd__fill_2
XTAP_TAPCELL_ROW_93_1138 VGND VPWR sky130_fd_sc_hd__tapvpwrvgnd_1
XFILLER_0_11_417 VGND VGND VPWR VPWR sky130_fd_sc_hd__fill_1
X_2460_ tree_instances\[4\].u_tree.pipeline_current_node\[0\]\[8\] tree_instances\[4\].u_tree.pipeline_current_node\[0\]\[7\]
+ VGND VGND VPWR VPWR _1811_ sky130_fd_sc_hd__nor2_1
XFILLER_0_23_299 VPWR VGND VPWR VGND sky130_ef_sc_hd__decap_12
X_2391_ tree_instances\[6\].u_tree.tree_state\[3\] VGND VGND VPWR VPWR _1750_ sky130_fd_sc_hd__buf_2
X_4130_ _1434_ VGND VGND VPWR VPWR _1436_ sky130_fd_sc_hd__clkbuf_1
XANTENNA__3081__A _0726_ VGND VGND VPWR VPWR sky130_fd_sc_hd__diode_2
XFILLER_0_3_25 VGND VGND VPWR VPWR sky130_fd_sc_hd__fill_2
X_4061_ _1392_ VGND VGND VPWR VPWR _0456_ sky130_fd_sc_hd__clkbuf_1
XFILLER_0_3_69 VGND VGND VPWR VPWR sky130_fd_sc_hd__fill_1
X_3012_ current_voting_frame\[1\] VGND VGND VPWR VPWR _0684_ sky130_fd_sc_hd__inv_2
XFILLER_0_78_439 VGND VGND VPWR VPWR sky130_fd_sc_hd__fill_2
XFILLER_0_64_99 VGND VGND VPWR VPWR sky130_fd_sc_hd__decap_8
XANTENNA__4217__A1 _0674_ VGND VGND VPWR VPWR sky130_fd_sc_hd__diode_2
XFILLER_0_58_141 VPWR VGND VPWR VGND sky130_ef_sc_hd__decap_12
XFILLER_0_80_43 VGND VGND VPWR VPWR sky130_fd_sc_hd__fill_1
X_3914_ _1309_ VGND VGND VPWR VPWR _0392_ sky130_fd_sc_hd__clkbuf_1
XFILLER_0_58_174 VGND VGND VPWR VPWR sky130_fd_sc_hd__fill_1
XFILLER_0_19_517 VPWR VGND VPWR VGND sky130_ef_sc_hd__decap_12
XFILLER_0_19_539 VGND VGND VPWR VPWR sky130_fd_sc_hd__decap_3
XFILLER_0_46_303 VGND VGND VPWR VPWR sky130_fd_sc_hd__decap_4
XFILLER_0_46_314 VGND VGND VPWR VPWR sky130_fd_sc_hd__decap_8
XFILLER_0_73_122 VGND VGND VPWR VPWR sky130_fd_sc_hd__fill_2
X_4894_ clknet_leaf_40_clk _0566_ net10 VGND VGND VPWR VPWR tree_instances\[20\].u_tree.ready_for_next
+ sky130_fd_sc_hd__dfstp_1
XFILLER_0_46_358 VGND VGND VPWR VPWR sky130_fd_sc_hd__fill_1
XFILLER_0_13_81 VGND VGND VPWR VPWR sky130_fd_sc_hd__decap_8
XFILLER_0_6_433 VPWR VGND VPWR VGND sky130_ef_sc_hd__decap_12
XFILLER_0_27_561 VPWR VGND VPWR VGND sky130_ef_sc_hd__decap_12
X_3845_ _1266_ VGND VGND VPWR VPWR _0366_ sky130_fd_sc_hd__clkbuf_1
XFILLER_0_73_188 VPWR VGND VPWR VGND sky130_ef_sc_hd__decap_12
XFILLER_0_6_477 VPWR VGND VPWR VGND sky130_ef_sc_hd__decap_12
X_3776_ tree_instances\[9\].u_tree.pipeline_valid\[0\] tree_instances\[9\].u_tree.tree_state\[0\]
+ VGND VGND VPWR VPWR _1230_ sky130_fd_sc_hd__nand2_1
XFILLER_0_89_63 VGND VGND VPWR VPWR sky130_fd_sc_hd__fill_2
X_2727_ _2042_ VGND VGND VPWR VPWR _0102_ sky130_fd_sc_hd__clkbuf_1
XFILLER_0_14_244 VGND VGND VPWR VPWR sky130_fd_sc_hd__fill_2
XFILLER_0_73_3 VGND VGND VPWR VPWR sky130_fd_sc_hd__decap_8
X_2658_ tree_instances\[19\].u_tree.pipeline_current_node\[0\]\[0\] VGND VGND VPWR
+ VPWR _1980_ sky130_fd_sc_hd__clkbuf_1
XANTENNA__4622__RESET_B net10 VGND VGND VPWR VPWR sky130_fd_sc_hd__diode_2
X_2589_ tree_instances\[1\].u_tree.pipeline_current_node\[0\]\[6\] VGND VGND VPWR
+ VPWR _1922_ sky130_fd_sc_hd__inv_2
X_4328_ state\[1\] _1546_ VGND VGND VPWR VPWR _0568_ sky130_fd_sc_hd__nor2_1
XANTENNA_input1_A feature_valid VGND VGND VPWR VPWR sky130_fd_sc_hd__diode_2
X_4259_ tree_instances\[19\].u_tree.pipeline_frame_id\[0\]\[0\] _0664_ _0022_ VGND
+ VGND VPWR VPWR _1512_ sky130_fd_sc_hd__mux2_1
XFILLER_0_96_225 VPWR VGND VPWR VGND sky130_ef_sc_hd__decap_12
XTAP_TAPCELL_ROW_81_1020 VGND VPWR sky130_fd_sc_hd__tapvpwrvgnd_1
XTAP_TAPCELL_ROW_25_456 VGND VPWR sky130_fd_sc_hd__tapvpwrvgnd_1
XFILLER_0_37_314 VPWR VGND VPWR VGND sky130_ef_sc_hd__decap_12
XFILLER_0_49_152 VGND VGND VPWR VPWR sky130_fd_sc_hd__fill_1
XTAP_TAPCELL_ROW_53_743 VGND VPWR sky130_fd_sc_hd__tapvpwrvgnd_1
XFILLER_0_37_358 VPWR VGND VPWR VGND sky130_ef_sc_hd__decap_12
XFILLER_0_64_177 VGND VGND VPWR VPWR sky130_fd_sc_hd__decap_3
XANTENNA__2989__B tree_instances\[17\].u_tree.ready_for_next VGND VGND VPWR VPWR sky130_fd_sc_hd__diode_2
XFILLER_0_45_391 VGND VGND VPWR VPWR sky130_fd_sc_hd__fill_1
XFILLER_0_60_383 VGND VGND VPWR VPWR sky130_fd_sc_hd__decap_3
XFILLER_0_60_361 VGND VGND VPWR VPWR sky130_fd_sc_hd__decap_3
XFILLER_0_20_247 VGND VGND VPWR VPWR sky130_fd_sc_hd__decap_4
XANTENNA__4363__RESET_B net12 VGND VGND VPWR VPWR sky130_fd_sc_hd__diode_2
XPHY_EDGE_ROW_0_Left_97 VGND VGND VPWR VPWR sky130_fd_sc_hd__decap_3
XANTENNA_clkbuf_leaf_8_clk_A clknet_3_3__leaf_clk VGND VGND VPWR VPWR sky130_fd_sc_hd__diode_2
XFILLER_0_87_225 VGND VGND VPWR VPWR sky130_fd_sc_hd__fill_2
XFILLER_0_55_100 VGND VGND VPWR VPWR sky130_fd_sc_hd__fill_1
XFILLER_0_83_497 VGND VGND VPWR VPWR sky130_fd_sc_hd__decap_4
X_3630_ _1142_ _1139_ VGND VGND VPWR VPWR _1143_ sky130_fd_sc_hd__and2_1
X_3561_ _1095_ VGND VGND VPWR VPWR _1096_ sky130_fd_sc_hd__clkbuf_2
XANTENNA__3186__A1 _0689_ VGND VGND VPWR VPWR sky130_fd_sc_hd__diode_2
XFILLER_0_59_22 VGND VGND VPWR VPWR sky130_fd_sc_hd__decap_8
XFILLER_0_59_11 VGND VGND VPWR VPWR sky130_fd_sc_hd__decap_3
XFILLER_0_3_447 VGND VGND VPWR VPWR sky130_fd_sc_hd__fill_1
X_2512_ tree_instances\[13\].u_tree.pipeline_current_node\[0\]\[0\] VGND VGND VPWR
+ VPWR _1857_ sky130_fd_sc_hd__inv_2
X_3492_ tree_instances\[12\].u_tree.tree_state\[0\] _1578_ VGND VGND VPWR VPWR _1050_
+ sky130_fd_sc_hd__nand2_1
XFILLER_0_59_66 VGND VGND VPWR VPWR sky130_fd_sc_hd__fill_2
XFILLER_0_59_55 VGND VGND VPWR VPWR sky130_fd_sc_hd__fill_1
XFILLER_0_11_225 VPWR VGND VPWR VGND sky130_ef_sc_hd__decap_12
X_2443_ tree_instances\[10\].u_tree.pipeline_current_node\[0\]\[5\] VGND VGND VPWR
+ VPWR _1796_ sky130_fd_sc_hd__clkbuf_1
X_2374_ tree_instances\[14\].u_tree.pipeline_current_node\[0\]\[7\] VGND VGND VPWR
+ VPWR _1735_ sky130_fd_sc_hd__clkbuf_1
XFILLER_0_75_43 VGND VGND VPWR VPWR sky130_fd_sc_hd__decap_4
X_4113_ _1729_ _1419_ _1397_ tree_instances\[16\].u_tree.ready_for_next VGND VGND
+ VPWR VPWR _0481_ sky130_fd_sc_hd__a22o_1
X_4044_ _1328_ _1375_ VGND VGND VPWR VPWR _1384_ sky130_fd_sc_hd__and2_1
XTAP_TAPCELL_ROW_67_879 VGND VPWR sky130_fd_sc_hd__tapvpwrvgnd_1
XTAP_TAPCELL_ROW_50_713 VGND VPWR sky130_fd_sc_hd__tapvpwrvgnd_1
XFILLER_0_74_475 VGND VGND VPWR VPWR sky130_fd_sc_hd__fill_1
X_4877_ clknet_leaf_40_clk _0549_ net10 VGND VGND VPWR VPWR tree_instances\[20\].u_tree.pipeline_current_node\[0\]\[2\]
+ sky130_fd_sc_hd__dfrtp_1
XANTENNA__4874__RESET_B net10 VGND VGND VPWR VPWR sky130_fd_sc_hd__diode_2
XTAP_TAPCELL_ROW_22_426 VGND VPWR sky130_fd_sc_hd__tapvpwrvgnd_1
XFILLER_0_61_125 VGND VGND VPWR VPWR sky130_fd_sc_hd__fill_2
X_3828_ _1257_ VGND VGND VPWR VPWR _0358_ sky130_fd_sc_hd__clkbuf_1
XFILLER_0_15_553 VGND VGND VPWR VPWR sky130_fd_sc_hd__decap_6
XANTENNA__4803__RESET_B net13 VGND VGND VPWR VPWR sky130_fd_sc_hd__diode_2
XPHY_EDGE_ROW_18_Left_115 VGND VGND VPWR VPWR sky130_fd_sc_hd__decap_3
XFILLER_0_30_523 VGND VGND VPWR VPWR sky130_fd_sc_hd__decap_8
X_3759_ _1221_ VGND VGND VPWR VPWR _0325_ sky130_fd_sc_hd__clkbuf_1
XFILLER_0_69_225 VGND VGND VPWR VPWR sky130_fd_sc_hd__decap_4
XPHY_EDGE_ROW_27_Left_124 VGND VGND VPWR VPWR sky130_fd_sc_hd__decap_3
XTAP_TAPCELL_ROW_38_592 VGND VPWR sky130_fd_sc_hd__tapvpwrvgnd_1
XFILLER_0_65_420 VGND VGND VPWR VPWR sky130_fd_sc_hd__fill_2
XFILLER_0_37_111 VGND VGND VPWR VPWR sky130_fd_sc_hd__fill_1
XFILLER_0_92_261 VGND VGND VPWR VPWR sky130_fd_sc_hd__fill_1
XFILLER_0_37_144 VGND VGND VPWR VPWR sky130_fd_sc_hd__fill_2
XFILLER_0_37_166 VGND VGND VPWR VPWR sky130_fd_sc_hd__fill_2
XFILLER_0_92_294 VPWR VGND VPWR VGND sky130_ef_sc_hd__decap_12
XFILLER_0_92_272 VPWR VGND VPWR VGND sky130_ef_sc_hd__decap_12
XFILLER_0_65_486 VGND VGND VPWR VPWR sky130_fd_sc_hd__fill_2
XFILLER_0_25_317 VGND VGND VPWR VPWR sky130_fd_sc_hd__fill_2
XFILLER_0_80_456 VPWR VGND VPWR VGND sky130_ef_sc_hd__decap_12
XFILLER_0_20_27 VGND VGND VPWR VPWR sky130_fd_sc_hd__fill_1
XPHY_EDGE_ROW_36_Left_133 VGND VGND VPWR VPWR sky130_fd_sc_hd__decap_3
XFILLER_0_40_309 VPWR VGND VPWR VGND sky130_ef_sc_hd__decap_12
XFILLER_0_60_191 VGND VGND VPWR VPWR sky130_fd_sc_hd__decap_4
XFILLER_0_0_417 VGND VGND VPWR VPWR sky130_fd_sc_hd__decap_3
XTAP_TAPCELL_ROW_90_1108 VGND VPWR sky130_fd_sc_hd__tapvpwrvgnd_1
XPHY_EDGE_ROW_45_Left_142 VGND VGND VPWR VPWR sky130_fd_sc_hd__decap_3
XFILLER_0_45_57 VPWR VGND VPWR VGND sky130_ef_sc_hd__decap_12
XFILLER_0_88_567 VGND VGND VPWR VPWR sky130_fd_sc_hd__decap_6
XTAP_TAPCELL_ROW_64_849 VGND VPWR sky130_fd_sc_hd__tapvpwrvgnd_1
XFILLER_0_0_15 VPWR VGND VPWR VGND sky130_ef_sc_hd__decap_12
X_4800_ clknet_leaf_54_clk _0487_ net13 VGND VGND VPWR VPWR tree_instances\[17\].u_tree.pipeline_current_node\[0\]\[4\]
+ sky130_fd_sc_hd__dfrtp_1
XFILLER_0_68_291 VGND VGND VPWR VPWR sky130_fd_sc_hd__fill_1
X_2992_ net1 _1646_ _0668_ VGND VGND VPWR VPWR _0669_ sky130_fd_sc_hd__and3_1
X_4731_ clknet_leaf_29_clk _0429_ net11 VGND VGND VPWR VPWR tree_instances\[14\].u_tree.pipeline_frame_id\[0\]\[0\]
+ sky130_fd_sc_hd__dfrtp_1
XFILLER_0_71_423 VGND VGND VPWR VPWR sky130_fd_sc_hd__fill_2
XFILLER_0_28_177 VPWR VGND VPWR VGND sky130_ef_sc_hd__decap_12
X_4662_ clknet_leaf_11_clk _0367_ tree_instances\[0\].u_tree.rst_n VGND VGND VPWR
+ VPWR tree_instances\[11\].u_tree.pipeline_frame_id\[0\]\[1\] sky130_fd_sc_hd__dfrtp_1
XPHY_EDGE_ROW_54_Left_151 VGND VGND VPWR VPWR sky130_fd_sc_hd__decap_3
X_3613_ _1131_ VGND VGND VPWR VPWR _0269_ sky130_fd_sc_hd__clkbuf_1
XFILLER_0_9_57 VGND VGND VPWR VPWR sky130_fd_sc_hd__decap_3
XFILLER_0_71_489 VGND VGND VPWR VPWR sky130_fd_sc_hd__fill_2
X_4593_ clknet_leaf_9_clk _0313_ net12 VGND VGND VPWR VPWR tree_instances\[8\].u_tree.ready_for_next
+ sky130_fd_sc_hd__dfstp_1
XFILLER_0_12_545 VPWR VGND VPWR VGND sky130_ef_sc_hd__decap_12
XFILLER_0_3_255 VGND VGND VPWR VPWR sky130_fd_sc_hd__fill_1
X_3544_ _1085_ VGND VGND VPWR VPWR _0246_ sky130_fd_sc_hd__clkbuf_1
X_3475_ _1041_ VGND VGND VPWR VPWR _0221_ sky130_fd_sc_hd__clkbuf_1
X_2426_ _1779_ VGND VGND VPWR VPWR _1780_ sky130_fd_sc_hd__clkbuf_1
XFILLER_0_86_75 VGND VGND VPWR VPWR sky130_fd_sc_hd__decap_3
XPHY_EDGE_ROW_63_Left_160 VGND VGND VPWR VPWR sky130_fd_sc_hd__decap_3
X_2357_ tree_instances\[13\].u_tree.pipeline_current_node\[0\]\[3\] VGND VGND VPWR
+ VPWR _1720_ sky130_fd_sc_hd__buf_1
XFILLER_0_19_91 VGND VGND VPWR VPWR sky130_fd_sc_hd__fill_2
X_2288_ tree_instances\[8\].u_tree.pipeline_current_node\[0\]\[3\] VGND VGND VPWR
+ VPWR _1659_ sky130_fd_sc_hd__clkbuf_1
X_4027_ _1872_ _1374_ _0030_ tree_instances\[3\].u_tree.pipeline_valid\[0\] VGND VGND
+ VPWR VPWR _0440_ sky130_fd_sc_hd__o2bb2a_1
XFILLER_0_19_111 VGND VGND VPWR VPWR sky130_fd_sc_hd__fill_1
XTAP_TAPCELL_ROW_35_562 VGND VPWR sky130_fd_sc_hd__tapvpwrvgnd_1
XFILLER_0_81_209 VGND VGND VPWR VPWR sky130_fd_sc_hd__decap_3
XFILLER_0_47_453 VGND VGND VPWR VPWR sky130_fd_sc_hd__decap_4
XFILLER_0_47_497 VGND VGND VPWR VPWR sky130_fd_sc_hd__fill_2
XANTENNA__4304__S _0026_ VGND VGND VPWR VPWR sky130_fd_sc_hd__diode_2
XFILLER_0_7_561 VPWR VGND VPWR VGND sky130_ef_sc_hd__decap_12
XFILLER_0_62_489 VGND VGND VPWR VPWR sky130_fd_sc_hd__decap_6
XFILLER_0_22_309 VGND VGND VPWR VPWR sky130_fd_sc_hd__fill_2
XFILLER_0_30_331 VGND VGND VPWR VPWR sky130_fd_sc_hd__fill_2
XFILLER_0_42_180 VPWR VGND VPWR VGND sky130_ef_sc_hd__decap_12
XANTENNA__3322__A1 _0682_ VGND VGND VPWR VPWR sky130_fd_sc_hd__diode_2
XTAP_TAPCELL_ROW_7_276 VGND VPWR sky130_fd_sc_hd__tapvpwrvgnd_1
XTAP_TAPCELL_ROW_87_1081 VGND VPWR sky130_fd_sc_hd__tapvpwrvgnd_1
XANTENNA__4796__RESET_B tree_instances\[0\].u_tree.rst_n VGND VGND VPWR VPWR sky130_fd_sc_hd__diode_2
XANTENNA__4725__RESET_B net10 VGND VGND VPWR VPWR sky130_fd_sc_hd__diode_2
XTAP_TAPCELL_ROW_61_819 VGND VPWR sky130_fd_sc_hd__tapvpwrvgnd_1
XFILLER_0_65_272 VGND VGND VPWR VPWR sky130_fd_sc_hd__decap_8
XFILLER_0_53_412 VGND VGND VPWR VPWR sky130_fd_sc_hd__fill_2
XFILLER_0_25_169 VGND VGND VPWR VPWR sky130_fd_sc_hd__fill_1
XFILLER_0_40_139 VGND VGND VPWR VPWR sky130_fd_sc_hd__fill_1
XFILLER_0_0_225 VPWR VGND VPWR VGND sky130_ef_sc_hd__decap_12
X_3260_ _0917_ VGND VGND VPWR VPWR _0130_ sky130_fd_sc_hd__clkbuf_1
X_2211_ _1589_ _1590_ VGND VGND VPWR VPWR _1591_ sky130_fd_sc_hd__nor2_1
X_3191_ _0733_ tree_instances\[13\].u_tree.frame_id_out\[1\] VGND VGND VPWR VPWR _0863_
+ sky130_fd_sc_hd__xor2_1
XTAP_TAPCELL_ROW_77_974 VGND VPWR sky130_fd_sc_hd__tapvpwrvgnd_1
XTAP_TAPCELL_ROW_49_698 VGND VPWR sky130_fd_sc_hd__tapvpwrvgnd_1
XFILLER_0_88_386 VGND VGND VPWR VPWR sky130_fd_sc_hd__decap_3
XFILLER_0_72_66 VPWR VGND VPWR VGND sky130_ef_sc_hd__decap_12
XANTENNA__4466__RESET_B net9 VGND VGND VPWR VPWR sky130_fd_sc_hd__diode_2
XTAP_TAPCELL_ROW_32_532 VGND VPWR sky130_fd_sc_hd__tapvpwrvgnd_1
XFILLER_0_56_250 VGND VGND VPWR VPWR sky130_fd_sc_hd__fill_2
X_4714_ clknet_leaf_1_clk _0417_ net9 VGND VGND VPWR VPWR tree_instances\[13\].u_tree.frame_id_out\[4\]
+ sky130_fd_sc_hd__dfrtp_1
X_2975_ _0654_ VGND VGND VPWR VPWR _0655_ sky130_fd_sc_hd__clkbuf_4
XFILLER_0_71_242 VGND VGND VPWR VPWR sky130_fd_sc_hd__fill_2
XFILLER_0_71_220 VGND VGND VPWR VPWR sky130_fd_sc_hd__fill_1
XFILLER_0_44_434 VPWR VGND VPWR VGND sky130_ef_sc_hd__decap_12
XFILLER_0_4_531 VGND VGND VPWR VPWR sky130_fd_sc_hd__fill_1
XFILLER_0_44_489 VGND VGND VPWR VPWR sky130_fd_sc_hd__decap_8
X_4645_ clknet_leaf_4_clk _0086_ tree_instances\[0\].u_tree.rst_n VGND VGND VPWR VPWR
+ tree_instances\[10\].u_tree.prediction_valid sky130_fd_sc_hd__dfrtp_1
X_4576_ clknet_leaf_16_clk _0296_ net11 VGND VGND VPWR VPWR tree_instances\[8\].u_tree.pipeline_current_node\[0\]\[2\]
+ sky130_fd_sc_hd__dfrtp_1
XANTENNA__3001__B1 _0675_ VGND VGND VPWR VPWR sky130_fd_sc_hd__diode_2
XFILLER_0_21_92 VPWR VGND VPWR VGND sky130_ef_sc_hd__decap_12
X_3527_ tree_instances\[5\].u_tree.pipeline_current_node\[0\]\[7\] _1054_ VGND VGND
+ VPWR VPWR _1077_ sky130_fd_sc_hd__and2_1
XANTENNA_clkbuf_leaf_33_clk_A clknet_3_7__leaf_clk VGND VGND VPWR VPWR sky130_fd_sc_hd__diode_2
X_3458_ _2103_ _1029_ VGND VGND VPWR VPWR _1033_ sky130_fd_sc_hd__and2_1
X_2409_ tree_instances\[5\].u_tree.pipeline_current_node\[0\]\[7\] tree_instances\[5\].u_tree.pipeline_current_node\[0\]\[8\]
+ VGND VGND VPWR VPWR _1766_ sky130_fd_sc_hd__nor2_1
X_3389_ _0991_ VGND VGND VPWR VPWR _0185_ sky130_fd_sc_hd__clkbuf_1
XTAP_TAPCELL_ROW_4_246 VGND VPWR sky130_fd_sc_hd__tapvpwrvgnd_1
XANTENNA_clkbuf_leaf_48_clk_A clknet_3_5__leaf_clk VGND VGND VPWR VPWR sky130_fd_sc_hd__diode_2
XFILLER_0_67_526 VGND VGND VPWR VPWR sky130_fd_sc_hd__decap_3
XFILLER_0_39_217 VGND VGND VPWR VPWR sky130_fd_sc_hd__decap_6
XFILLER_0_94_312 VGND VGND VPWR VPWR sky130_fd_sc_hd__fill_2
XFILLER_0_1_91 VPWR VGND VPWR VGND sky130_ef_sc_hd__decap_12
XFILLER_0_82_518 VPWR VGND VPWR VGND sky130_ef_sc_hd__decap_12
XFILLER_0_54_209 VPWR VGND VPWR VGND sky130_ef_sc_hd__decap_12
XFILLER_0_90_540 VPWR VGND VPWR VGND sky130_ef_sc_hd__decap_12
XFILLER_0_62_231 VGND VGND VPWR VPWR sky130_fd_sc_hd__fill_2
XFILLER_0_7_380 VGND VGND VPWR VPWR sky130_fd_sc_hd__fill_1
XFILLER_0_22_117 VGND VGND VPWR VPWR sky130_fd_sc_hd__decap_3
XFILLER_0_30_161 VGND VGND VPWR VPWR sky130_fd_sc_hd__fill_2
XFILLER_0_26_15 VPWR VGND VPWR VGND sky130_ef_sc_hd__decap_12
XTAP_TAPCELL_ROW_74_944 VGND VPWR sky130_fd_sc_hd__tapvpwrvgnd_1
XFILLER_0_58_504 VGND VGND VPWR VPWR sky130_fd_sc_hd__fill_2
XFILLER_0_85_334 VGND VGND VPWR VPWR sky130_fd_sc_hd__fill_2
XTAP_TAPCELL_ROW_46_668 VGND VPWR sky130_fd_sc_hd__tapvpwrvgnd_1
XFILLER_0_38_283 VGND VGND VPWR VPWR sky130_fd_sc_hd__fill_2
X_2760_ _2069_ VGND VGND VPWR VPWR _0088_ sky130_fd_sc_hd__clkbuf_1
XFILLER_0_26_445 VGND VGND VPWR VPWR sky130_fd_sc_hd__decap_8
X_2691_ _2009_ VGND VGND VPWR VPWR _2010_ sky130_fd_sc_hd__clkbuf_1
XFILLER_0_81_573 VGND VGND VPWR VPWR sky130_fd_sc_hd__fill_1
X_4430_ clknet_leaf_56_clk _0176_ net9 VGND VGND VPWR VPWR tree_instances\[2\].u_tree.pipeline_current_node\[0\]\[8\]
+ sky130_fd_sc_hd__dfrtp_1
XFILLER_0_41_437 VGND VGND VPWR VPWR sky130_fd_sc_hd__decap_3
XTAP_TAPCELL_ROW_96_1169 VGND VPWR sky130_fd_sc_hd__tapvpwrvgnd_1
XFILLER_0_67_22 VGND VGND VPWR VPWR sky130_fd_sc_hd__fill_2
XFILLER_0_67_11 VGND VGND VPWR VPWR sky130_fd_sc_hd__fill_2
XFILLER_0_21_161 VGND VGND VPWR VPWR sky130_fd_sc_hd__decap_6
X_4361_ clknet_leaf_7_clk _0121_ net12 VGND VGND VPWR VPWR current_voting_frame\[0\]
+ sky130_fd_sc_hd__dfrtp_4
X_3312_ tree_instances\[1\].u_tree.pipeline_current_node\[0\]\[8\] _0935_ VGND VGND
+ VPWR VPWR _0945_ sky130_fd_sc_hd__and2_1
X_4292_ _2146_ _1524_ VGND VGND VPWR VPWR _1529_ sky130_fd_sc_hd__and2_1
XFILLER_0_6_69 VPWR VGND VPWR VGND sky130_ef_sc_hd__decap_12
XFILLER_0_67_88 VPWR VGND VPWR VGND sky130_ef_sc_hd__decap_12
X_3243_ _0906_ _0907_ VGND VGND VPWR VPWR _0123_ sky130_fd_sc_hd__nor2_1
XTAP_TAPCELL_ROW_1_216 VGND VPWR sky130_fd_sc_hd__tapvpwrvgnd_1
X_3174_ tree_instances\[20\].u_tree.frame_id_out\[1\] _0650_ VGND VGND VPWR VPWR _0846_
+ sky130_fd_sc_hd__and2b_1
XANTENNA__4647__RESET_B net9 VGND VGND VPWR VPWR sky130_fd_sc_hd__diode_2
XFILLER_0_16_81 VGND VGND VPWR VPWR sky130_fd_sc_hd__decap_3
XTAP_TAPCELL_ROW_17_381 VGND VPWR sky130_fd_sc_hd__tapvpwrvgnd_1
XFILLER_0_91_337 VGND VGND VPWR VPWR sky130_fd_sc_hd__fill_2
X_2958_ _0641_ _1935_ VGND VGND VPWR VPWR _0642_ sky130_fd_sc_hd__or2_1
XFILLER_0_44_253 VPWR VGND VPWR VGND sky130_ef_sc_hd__decap_12
X_4628_ clknet_leaf_2_clk _0338_ net9 VGND VGND VPWR VPWR tree_instances\[10\].u_tree.pipeline_current_node\[0\]\[3\]
+ sky130_fd_sc_hd__dfrtp_1
XFILLER_0_32_426 VGND VGND VPWR VPWR sky130_fd_sc_hd__fill_2
X_2889_ _0595_ VGND VGND VPWR VPWR _0596_ sky130_fd_sc_hd__clkbuf_1
X_4559_ clknet_leaf_66_clk _0280_ tree_instances\[0\].u_tree.rst_n VGND VGND VPWR
+ VPWR tree_instances\[7\].u_tree.pipeline_current_node\[0\]\[6\] sky130_fd_sc_hd__dfrtp_1
XFILLER_0_40_492 VPWR VGND VPWR VGND sky130_ef_sc_hd__decap_12
XANTENNA__4388__RESET_B net11 VGND VGND VPWR VPWR sky130_fd_sc_hd__diode_2
XTAP_TAPCELL_ROW_84_1051 VGND VPWR sky130_fd_sc_hd__tapvpwrvgnd_1
XTAP_TAPCELL_ROW_71_914 VGND VPWR sky130_fd_sc_hd__tapvpwrvgnd_1
XFILLER_0_67_334 VGND VGND VPWR VPWR sky130_fd_sc_hd__fill_2
XFILLER_0_67_345 VGND VGND VPWR VPWR sky130_fd_sc_hd__fill_1
XTAP_TAPCELL_ROW_43_638 VGND VPWR sky130_fd_sc_hd__tapvpwrvgnd_1
XFILLER_0_94_197 VGND VGND VPWR VPWR sky130_fd_sc_hd__decap_8
XFILLER_0_2_309 VPWR VGND VPWR VGND sky130_ef_sc_hd__decap_12
XFILLER_0_50_223 VGND VGND VPWR VPWR sky130_fd_sc_hd__fill_2
XFILLER_0_23_459 VGND VGND VPWR VPWR sky130_fd_sc_hd__decap_6
Xoutput4 net4 VGND VGND VPWR VPWR frame_id_out[2] sky130_fd_sc_hd__buf_8
XFILLER_0_31_470 VGND VGND VPWR VPWR sky130_fd_sc_hd__fill_2
XANTENNA__4740__RESET_B net10 VGND VGND VPWR VPWR sky130_fd_sc_hd__diode_2
X_3930_ _1319_ VGND VGND VPWR VPWR _1320_ sky130_fd_sc_hd__clkbuf_1
XFILLER_0_58_356 VGND VGND VPWR VPWR sky130_fd_sc_hd__fill_2
X_3861_ _1274_ VGND VGND VPWR VPWR _0374_ sky130_fd_sc_hd__clkbuf_1
XTAP_TAPCELL_ROW_14_351 VGND VPWR sky130_fd_sc_hd__tapvpwrvgnd_1
X_2812_ tree_instances\[3\].u_tree.pipeline_current_node\[0\]\[4\] VGND VGND VPWR
+ VPWR _2116_ sky130_fd_sc_hd__clkbuf_1
XFILLER_0_5_103 VGND VGND VPWR VPWR sky130_fd_sc_hd__decap_8
X_3792_ _0599_ _1232_ VGND VGND VPWR VPWR _1239_ sky130_fd_sc_hd__and2_1
XFILLER_0_54_540 VGND VGND VPWR VPWR sky130_fd_sc_hd__fill_2
X_2743_ _2052_ VGND VGND VPWR VPWR _2054_ sky130_fd_sc_hd__clkbuf_1
XFILLER_0_5_169 VGND VGND VPWR VPWR sky130_fd_sc_hd__decap_3
XFILLER_0_41_223 VGND VGND VPWR VPWR sky130_fd_sc_hd__fill_1
X_2674_ _1865_ VGND VGND VPWR VPWR _1995_ sky130_fd_sc_hd__clkbuf_1
XFILLER_0_41_256 VGND VGND VPWR VPWR sky130_fd_sc_hd__fill_1
X_4413_ clknet_leaf_20_clk _0160_ net11 VGND VGND VPWR VPWR tree_instances\[1\].u_tree.pipeline_frame_id\[0\]\[4\]
+ sky130_fd_sc_hd__dfrtp_1
XFILLER_0_78_43 VPWR VGND VPWR VGND sky130_ef_sc_hd__decap_12
XFILLER_0_1_320 VPWR VGND VPWR VGND sky130_ef_sc_hd__decap_12
XFILLER_0_78_98 VPWR VGND VPWR VGND sky130_ef_sc_hd__decap_12
XFILLER_0_1_364 VGND VGND VPWR VPWR sky130_fd_sc_hd__fill_2
X_4344_ clknet_leaf_12_clk _0047_ tree_instances\[0\].u_tree.rst_n VGND VGND VPWR
+ VPWR tree_instances\[11\].u_tree.tree_state\[3\] sky130_fd_sc_hd__dfrtp_1
XFILLER_0_1_397 VPWR VGND VPWR VGND sky130_ef_sc_hd__decap_12
X_4275_ tree_instances\[19\].u_tree.frame_id_out\[3\] tree_instances\[19\].u_tree.pipeline_frame_id\[0\]\[3\]
+ _1970_ VGND VGND VPWR VPWR _1520_ sky130_fd_sc_hd__mux2_1
XANTENNA__4828__RESET_B net10 VGND VGND VPWR VPWR sky130_fd_sc_hd__diode_2
X_3226_ _0892_ _0893_ VGND VGND VPWR VPWR _0895_ sky130_fd_sc_hd__nor2_1
X_3157_ _0694_ tree_instances\[10\].u_tree.frame_id_out\[0\] tree_instances\[10\].u_tree.frame_id_out\[4\]
+ _0696_ VGND VGND VPWR VPWR _0829_ sky130_fd_sc_hd__a22o_1
XFILLER_0_68_109 VPWR VGND VPWR VGND sky130_ef_sc_hd__decap_12
XANTENNA__4481__RESET_B tree_instances\[0\].u_tree.rst_n VGND VGND VPWR VPWR sky130_fd_sc_hd__diode_2
XANTENNA__4410__RESET_B net11 VGND VGND VPWR VPWR sky130_fd_sc_hd__diode_2
X_3088_ _0655_ tree_instances\[18\].u_tree.frame_id_out\[2\] VGND VGND VPWR VPWR _0760_
+ sky130_fd_sc_hd__xor2_1
XFILLER_0_49_301 VGND VGND VPWR VPWR sky130_fd_sc_hd__decap_4
XFILLER_0_76_153 VGND VGND VPWR VPWR sky130_fd_sc_hd__fill_1
XTAP_TAPCELL_ROW_40_608 VGND VPWR sky130_fd_sc_hd__tapvpwrvgnd_1
XFILLER_0_49_378 VGND VGND VPWR VPWR sky130_fd_sc_hd__decap_6
XFILLER_0_91_167 VGND VGND VPWR VPWR sky130_fd_sc_hd__fill_1
XFILLER_0_9_497 VGND VGND VPWR VPWR sky130_fd_sc_hd__decap_6
XFILLER_0_17_264 VPWR VGND VPWR VGND sky130_ef_sc_hd__decap_12
XFILLER_0_32_201 VGND VGND VPWR VPWR sky130_fd_sc_hd__decap_8
XANTENNA__4312__S _1908_ VGND VGND VPWR VPWR sky130_fd_sc_hd__diode_2
XANTENNA__4569__RESET_B tree_instances\[0\].u_tree.rst_n VGND VGND VPWR VPWR sky130_fd_sc_hd__diode_2
XTAP_TAPCELL_ROW_28_487 VGND VPWR sky130_fd_sc_hd__tapvpwrvgnd_1
XFILLER_0_95_473 VPWR VGND VPWR VGND sky130_ef_sc_hd__decap_12
XFILLER_0_55_337 VGND VGND VPWR VPWR sky130_fd_sc_hd__decap_4
XFILLER_0_70_318 VGND VGND VPWR VPWR sky130_fd_sc_hd__fill_2
XTAP_TAPCELL_ROW_11_321 VGND VPWR sky130_fd_sc_hd__tapvpwrvgnd_1
XFILLER_0_36_573 VGND VGND VPWR VPWR sky130_fd_sc_hd__fill_1
XFILLER_0_63_381 VGND VGND VPWR VPWR sky130_fd_sc_hd__fill_2
XFILLER_0_23_223 VGND VGND VPWR VPWR sky130_fd_sc_hd__fill_1
XFILLER_0_23_245 VGND VGND VPWR VPWR sky130_fd_sc_hd__fill_2
XTAP_TAPCELL_ROW_93_1139 VGND VPWR sky130_fd_sc_hd__tapvpwrvgnd_1
XFILLER_0_23_289 VGND VGND VPWR VPWR sky130_fd_sc_hd__fill_1
X_2390_ tree_instances\[14\].u_tree.pipeline_current_node\[0\]\[8\] _1747_ _1749_
+ _1744_ tree_instances\[14\].u_tree.tree_state\[2\] VGND VGND VPWR VPWR _0011_ sky130_fd_sc_hd__o41a_1
XFILLER_0_48_35 VGND VGND VPWR VPWR sky130_fd_sc_hd__fill_2
X_4060_ tree_instances\[15\].u_tree.frame_id_out\[1\] tree_instances\[15\].u_tree.pipeline_frame_id\[0\]\[1\]
+ _1936_ VGND VGND VPWR VPWR _1392_ sky130_fd_sc_hd__mux2_1
X_3011_ complete_votes\[0\] _0645_ VGND VGND VPWR VPWR _0683_ sky130_fd_sc_hd__nand2_1
XFILLER_0_58_131 VGND VGND VPWR VPWR sky130_fd_sc_hd__decap_8
X_3913_ tree_instances\[12\].u_tree.frame_id_out\[0\] tree_instances\[12\].u_tree.pipeline_frame_id\[0\]\[0\]
+ _1579_ VGND VGND VPWR VPWR _1309_ sky130_fd_sc_hd__mux2_1
XFILLER_0_58_153 VGND VGND VPWR VPWR sky130_fd_sc_hd__decap_6
X_4893_ clknet_leaf_41_clk _0565_ net10 VGND VGND VPWR VPWR tree_instances\[20\].u_tree.frame_id_out\[4\]
+ sky130_fd_sc_hd__dfrtp_1
XFILLER_0_19_529 VGND VGND VPWR VPWR sky130_fd_sc_hd__fill_2
X_3844_ tree_instances\[11\].u_tree.pipeline_frame_id\[0\]\[0\] _1162_ _0006_ VGND
+ VGND VPWR VPWR _1266_ sky130_fd_sc_hd__mux2_1
XFILLER_0_61_307 VGND VGND VPWR VPWR sky130_fd_sc_hd__decap_6
XFILLER_0_6_445 VPWR VGND VPWR VGND sky130_ef_sc_hd__decap_12
XFILLER_0_27_573 VGND VGND VPWR VPWR sky130_fd_sc_hd__fill_1
X_3775_ _1649_ _1229_ _0610_ tree_instances\[9\].u_tree.ready_for_next VGND VGND VPWR
+ VPWR _0333_ sky130_fd_sc_hd__a22o_1
XFILLER_0_89_75 VGND VGND VPWR VPWR sky130_fd_sc_hd__fill_2
X_2726_ tree_instances\[6\].u_tree.prediction_valid _1750_ VGND VGND VPWR VPWR _2042_
+ sky130_fd_sc_hd__and2b_1
XFILLER_0_6_489 VPWR VGND VPWR VGND sky130_ef_sc_hd__decap_12
X_2657_ _1972_ VGND VGND VPWR VPWR _1979_ sky130_fd_sc_hd__clkbuf_1
XFILLER_0_14_289 VGND VGND VPWR VPWR sky130_fd_sc_hd__decap_3
XFILLER_0_66_3 VGND VGND VPWR VPWR sky130_fd_sc_hd__decap_8
X_2588_ _1917_ _1920_ VGND VGND VPWR VPWR _1921_ sky130_fd_sc_hd__nand2_1
XFILLER_0_10_462 VGND VGND VPWR VPWR sky130_fd_sc_hd__fill_1
X_4327_ _1547_ VGND VGND VPWR VPWR _0567_ sky130_fd_sc_hd__clkbuf_1
XANTENNA__4662__RESET_B tree_instances\[0\].u_tree.rst_n VGND VGND VPWR VPWR sky130_fd_sc_hd__diode_2
X_4258_ _1511_ VGND VGND VPWR VPWR _0534_ sky130_fd_sc_hd__clkbuf_1
X_3209_ _0689_ tree_instances\[5\].u_tree.frame_id_out\[3\] _0879_ _0880_ tree_instances\[5\].u_tree.prediction_valid
+ VGND VGND VPWR VPWR _0881_ sky130_fd_sc_hd__o221a_1
X_4189_ _1475_ VGND VGND VPWR VPWR _0501_ sky130_fd_sc_hd__clkbuf_1
XFILLER_0_96_237 VPWR VGND VPWR VGND sky130_ef_sc_hd__decap_12
XTAP_TAPCELL_ROW_81_1021 VGND VPWR sky130_fd_sc_hd__tapvpwrvgnd_1
XFILLER_0_77_473 VGND VGND VPWR VPWR sky130_fd_sc_hd__fill_2
XTAP_TAPCELL_ROW_25_457 VGND VPWR sky130_fd_sc_hd__tapvpwrvgnd_1
XFILLER_0_49_164 VGND VGND VPWR VPWR sky130_fd_sc_hd__fill_2
XFILLER_0_92_421 VGND VGND VPWR VPWR sky130_fd_sc_hd__fill_2
XFILLER_0_37_326 VGND VGND VPWR VPWR sky130_fd_sc_hd__decap_4
XFILLER_0_37_337 VGND VGND VPWR VPWR sky130_fd_sc_hd__decap_3
XFILLER_0_18_573 VGND VGND VPWR VPWR sky130_fd_sc_hd__fill_1
XFILLER_0_33_532 VGND VGND VPWR VPWR sky130_fd_sc_hd__decap_8
XFILLER_0_60_395 VGND VGND VPWR VPWR sky130_fd_sc_hd__decap_4
XANTENNA__3182__A _0726_ VGND VGND VPWR VPWR sky130_fd_sc_hd__diode_2
XFILLER_0_18_38 VGND VGND VPWR VPWR sky130_fd_sc_hd__decap_3
XANTENNA__4332__RESET_B net9 VGND VGND VPWR VPWR sky130_fd_sc_hd__diode_2
XPHY_EDGE_ROW_16_Right_16 VGND VGND VPWR VPWR sky130_fd_sc_hd__decap_3
XFILLER_0_95_281 VGND VGND VPWR VPWR sky130_fd_sc_hd__decap_4
XFILLER_0_55_123 VGND VGND VPWR VPWR sky130_fd_sc_hd__decap_3
XFILLER_0_36_381 VPWR VGND VPWR VGND sky130_ef_sc_hd__decap_12
X_3560_ tree_instances\[6\].u_tree.tree_state\[2\] tree_instances\[6\].u_tree.tree_state\[1\]
+ _0620_ VGND VGND VPWR VPWR _1095_ sky130_fd_sc_hd__or3_1
XFILLER_0_70_137 VGND VGND VPWR VPWR sky130_fd_sc_hd__decap_3
XPHY_EDGE_ROW_25_Right_25 VGND VGND VPWR VPWR sky130_fd_sc_hd__decap_3
X_2511_ _1836_ tree_instances\[3\].u_tree.tree_state\[2\] _1856_ tree_instances\[3\].u_tree.tree_state\[1\]
+ VGND VGND VPWR VPWR _0070_ sky130_fd_sc_hd__a31o_1
XFILLER_0_11_237 VPWR VGND VPWR VGND sky130_ef_sc_hd__decap_12
X_3491_ _1834_ _1049_ _0627_ tree_instances\[4\].u_tree.ready_for_next VGND VGND VPWR
+ VPWR _0229_ sky130_fd_sc_hd__a22o_1
X_2442_ tree_instances\[10\].u_tree.pipeline_current_node\[0\]\[4\] VGND VGND VPWR
+ VPWR _1795_ sky130_fd_sc_hd__clkbuf_1
X_2373_ _1732_ _1733_ VGND VGND VPWR VPWR _1734_ sky130_fd_sc_hd__nor2_1
X_4112_ _1730_ VGND VGND VPWR VPWR _1419_ sky130_fd_sc_hd__inv_2
X_4043_ _1383_ VGND VGND VPWR VPWR _0447_ sky130_fd_sc_hd__clkbuf_1
XPHY_EDGE_ROW_34_Right_34 VGND VGND VPWR VPWR sky130_fd_sc_hd__decap_3
XFILLER_0_91_54 VGND VGND VPWR VPWR sky130_fd_sc_hd__fill_2
XFILLER_0_46_101 VPWR VGND VPWR VGND sky130_ef_sc_hd__decap_12
X_4876_ clknet_leaf_40_clk _0548_ net10 VGND VGND VPWR VPWR tree_instances\[20\].u_tree.pipeline_current_node\[0\]\[1\]
+ sky130_fd_sc_hd__dfrtp_1
XTAP_TAPCELL_ROW_22_427 VGND VPWR sky130_fd_sc_hd__tapvpwrvgnd_1
XFILLER_0_34_329 VGND VGND VPWR VPWR sky130_fd_sc_hd__fill_2
XPHY_EDGE_ROW_43_Right_43 VGND VGND VPWR VPWR sky130_fd_sc_hd__decap_3
X_3827_ _2039_ _1255_ VGND VGND VPWR VPWR _1257_ sky130_fd_sc_hd__and2_1
X_3758_ tree_instances\[9\].u_tree.pipeline_frame_id\[0\]\[2\] _1165_ _0042_ VGND
+ VGND VPWR VPWR _1221_ sky130_fd_sc_hd__mux2_1
X_2709_ _2026_ VGND VGND VPWR VPWR _0100_ sky130_fd_sc_hd__clkbuf_1
X_3689_ _1181_ VGND VGND VPWR VPWR _0295_ sky130_fd_sc_hd__clkbuf_1
XANTENNA__4843__RESET_B net10 VGND VGND VPWR VPWR sky130_fd_sc_hd__diode_2
XFILLER_0_10_292 VGND VGND VPWR VPWR sky130_fd_sc_hd__decap_4
XPHY_EDGE_ROW_52_Right_52 VGND VGND VPWR VPWR sky130_fd_sc_hd__decap_3
XTAP_TAPCELL_ROW_38_593 VGND VPWR sky130_fd_sc_hd__tapvpwrvgnd_1
XPHY_EDGE_ROW_61_Right_61 VGND VGND VPWR VPWR sky130_fd_sc_hd__decap_3
XFILLER_0_52_126 VPWR VGND VPWR VGND sky130_ef_sc_hd__decap_12
XFILLER_0_80_468 VGND VGND VPWR VPWR sky130_fd_sc_hd__decap_8
XANTENNA__3177__A _0660_ VGND VGND VPWR VPWR sky130_fd_sc_hd__diode_2
XFILLER_0_21_502 VGND VGND VPWR VPWR sky130_fd_sc_hd__fill_2
XANTENNA__4584__RESET_B net12 VGND VGND VPWR VPWR sky130_fd_sc_hd__diode_2
XTAP_TAPCELL_ROW_90_1109 VGND VPWR sky130_fd_sc_hd__tapvpwrvgnd_1
XANTENNA__4513__RESET_B net12 VGND VGND VPWR VPWR sky130_fd_sc_hd__diode_2
XPHY_EDGE_ROW_70_Right_70 VGND VGND VPWR VPWR sky130_fd_sc_hd__decap_3
XFILLER_0_45_69 VPWR VGND VPWR VGND sky130_ef_sc_hd__decap_12
XFILLER_0_0_27 VGND VGND VPWR VPWR sky130_fd_sc_hd__fill_1
X_2991_ _1549_ _1552_ _0667_ VGND VGND VPWR VPWR _0668_ sky130_fd_sc_hd__and3_1
XFILLER_0_61_57 VPWR VGND VPWR VGND sky130_ef_sc_hd__decap_12
XFILLER_0_61_35 VPWR VGND VPWR VGND sky130_ef_sc_hd__decap_12
XFILLER_0_56_421 VGND VGND VPWR VPWR sky130_fd_sc_hd__decap_8
X_4730_ clknet_leaf_39_clk _0428_ net10 VGND VGND VPWR VPWR tree_instances\[14\].u_tree.pipeline_current_node\[0\]\[8\]
+ sky130_fd_sc_hd__dfrtp_1
XFILLER_0_28_189 VGND VGND VPWR VPWR sky130_fd_sc_hd__fill_1
X_4661_ clknet_leaf_10_clk _0366_ tree_instances\[0\].u_tree.rst_n VGND VGND VPWR
+ VPWR tree_instances\[11\].u_tree.pipeline_frame_id\[0\]\[0\] sky130_fd_sc_hd__dfrtp_1
X_3612_ tree_instances\[6\].u_tree.frame_id_out\[2\] tree_instances\[6\].u_tree.pipeline_frame_id\[0\]\[2\]
+ _1750_ VGND VGND VPWR VPWR _1131_ sky130_fd_sc_hd__mux2_1
XFILLER_0_71_446 VGND VGND VPWR VPWR sky130_fd_sc_hd__fill_2
X_4592_ clknet_leaf_13_clk _0312_ net12 VGND VGND VPWR VPWR tree_instances\[8\].u_tree.frame_id_out\[4\]
+ sky130_fd_sc_hd__dfrtp_1
X_3543_ tree_instances\[5\].u_tree.frame_id_out\[1\] tree_instances\[5\].u_tree.pipeline_frame_id\[0\]\[1\]
+ _1770_ VGND VGND VPWR VPWR _1085_ sky130_fd_sc_hd__mux2_1
XFILLER_0_51_181 VGND VGND VPWR VPWR sky130_fd_sc_hd__decap_3
XFILLER_0_12_557 VPWR VGND VPWR VGND sky130_ef_sc_hd__decap_12
XFILLER_0_10_83 VGND VGND VPWR VPWR sky130_fd_sc_hd__fill_1
X_3474_ tree_instances\[4\].u_tree.pipeline_frame_id\[0\]\[2\] _0675_ _0032_ VGND
+ VGND VPWR VPWR _1041_ sky130_fd_sc_hd__mux2_1
X_2425_ tree_instances\[16\].u_tree.pipeline_current_node\[0\]\[2\] VGND VGND VPWR
+ VPWR _1779_ sky130_fd_sc_hd__clkbuf_1
X_2356_ _1718_ VGND VGND VPWR VPWR _1719_ sky130_fd_sc_hd__clkbuf_1
XFILLER_0_19_81 VGND VGND VPWR VPWR sky130_fd_sc_hd__decap_4
X_2287_ _1657_ VGND VGND VPWR VPWR _1658_ sky130_fd_sc_hd__clkbuf_1
XFILLER_0_79_502 VGND VGND VPWR VPWR sky130_fd_sc_hd__fill_2
X_4026_ tree_instances\[3\].u_tree.pipeline_valid\[0\] tree_instances\[3\].u_tree.tree_state\[0\]
+ VGND VGND VPWR VPWR _1374_ sky130_fd_sc_hd__nand2_1
XFILLER_0_29_3 VGND VGND VPWR VPWR sky130_fd_sc_hd__decap_4
XANTENNA__3095__B2 _0647_ VGND VGND VPWR VPWR sky130_fd_sc_hd__diode_2
XFILLER_0_66_218 VGND VGND VPWR VPWR sky130_fd_sc_hd__decap_6
XTAP_TAPCELL_ROW_35_563 VGND VPWR sky130_fd_sc_hd__tapvpwrvgnd_1
XFILLER_0_74_251 VGND VGND VPWR VPWR sky130_fd_sc_hd__fill_1
X_4859_ clknet_leaf_28_clk _0540_ net13 VGND VGND VPWR VPWR tree_instances\[19\].u_tree.frame_id_out\[0\]
+ sky130_fd_sc_hd__dfrtp_1
XFILLER_0_7_573 VGND VGND VPWR VPWR sky130_fd_sc_hd__fill_1
XANTENNA_clkbuf_leaf_7_clk_A clknet_3_3__leaf_clk VGND VGND VPWR VPWR sky130_fd_sc_hd__diode_2
XFILLER_0_15_351 VGND VGND VPWR VPWR sky130_fd_sc_hd__decap_4
Xclkbuf_3_0__f_clk clknet_0_clk VGND VGND VPWR VPWR clknet_3_0__leaf_clk sky130_fd_sc_hd__clkbuf_16
XFILLER_0_42_170 VGND VGND VPWR VPWR sky130_fd_sc_hd__fill_2
XFILLER_0_30_365 VGND VGND VPWR VPWR sky130_fd_sc_hd__decap_4
XFILLER_0_42_192 VGND VGND VPWR VPWR sky130_fd_sc_hd__decap_4
XTAP_TAPCELL_ROW_7_277 VGND VPWR sky130_fd_sc_hd__tapvpwrvgnd_1
XFILLER_0_15_39 VGND VGND VPWR VPWR sky130_fd_sc_hd__fill_1
XTAP_TAPCELL_ROW_87_1082 VGND VPWR sky130_fd_sc_hd__tapvpwrvgnd_1
XFILLER_0_85_505 VGND VGND VPWR VPWR sky130_fd_sc_hd__decap_8
XFILLER_0_38_421 VGND VGND VPWR VPWR sky130_fd_sc_hd__fill_2
XFILLER_0_53_424 VGND VGND VPWR VPWR sky130_fd_sc_hd__decap_3
XFILLER_0_53_446 VGND VGND VPWR VPWR sky130_fd_sc_hd__fill_2
XFILLER_0_0_237 VPWR VGND VPWR VGND sky130_ef_sc_hd__decap_12
XFILLER_0_21_398 VPWR VGND VPWR VGND sky130_ef_sc_hd__decap_12
X_2210_ tree_instances\[9\].u_tree.pipeline_current_node\[0\]\[6\] VGND VGND VPWR
+ VPWR _1590_ sky130_fd_sc_hd__clkbuf_1
X_3190_ _0855_ _0858_ _0861_ VGND VGND VPWR VPWR _0862_ sky130_fd_sc_hd__and3_1
XFILLER_0_56_24 VGND VGND VPWR VPWR sky130_fd_sc_hd__fill_2
XTAP_TAPCELL_ROW_77_975 VGND VPWR sky130_fd_sc_hd__tapvpwrvgnd_1
XFILLER_0_88_321 VGND VGND VPWR VPWR sky130_fd_sc_hd__fill_1
XFILLER_0_72_23 VGND VGND VPWR VPWR sky130_fd_sc_hd__fill_2
XTAP_TAPCELL_ROW_49_699 VGND VPWR sky130_fd_sc_hd__tapvpwrvgnd_1
XFILLER_0_72_89 VGND VGND VPWR VPWR sky130_fd_sc_hd__fill_1
XFILLER_0_72_78 VGND VGND VPWR VPWR sky130_fd_sc_hd__decap_6
XFILLER_0_91_508 VPWR VGND VPWR VGND sky130_ef_sc_hd__decap_12
X_2974_ _0653_ VGND VGND VPWR VPWR _0654_ sky130_fd_sc_hd__buf_4
XFILLER_0_29_443 VGND VGND VPWR VPWR sky130_fd_sc_hd__fill_2
XTAP_TAPCELL_ROW_32_533 VGND VPWR sky130_fd_sc_hd__tapvpwrvgnd_1
X_4713_ clknet_leaf_4_clk _0416_ net9 VGND VGND VPWR VPWR tree_instances\[13\].u_tree.frame_id_out\[3\]
+ sky130_fd_sc_hd__dfrtp_1
XFILLER_0_44_446 VPWR VGND VPWR VGND sky130_ef_sc_hd__decap_12
XANTENNA__4435__RESET_B net13 VGND VGND VPWR VPWR sky130_fd_sc_hd__diode_2
X_4644_ clknet_leaf_4_clk _0354_ tree_instances\[0\].u_tree.rst_n VGND VGND VPWR VPWR
+ tree_instances\[10\].u_tree.ready_for_next sky130_fd_sc_hd__dfstp_1
X_4575_ clknet_leaf_16_clk _0295_ net12 VGND VGND VPWR VPWR tree_instances\[8\].u_tree.pipeline_current_node\[0\]\[1\]
+ sky130_fd_sc_hd__dfrtp_1
XANTENNA__3001__A1 _0673_ VGND VGND VPWR VPWR sky130_fd_sc_hd__diode_2
X_3526_ _1076_ VGND VGND VPWR VPWR _0237_ sky130_fd_sc_hd__clkbuf_1
XFILLER_0_12_365 VPWR VGND VPWR VGND sky130_ef_sc_hd__decap_12
X_3457_ _1032_ VGND VGND VPWR VPWR _0212_ sky130_fd_sc_hd__clkbuf_1
X_2408_ tree_instances\[5\].u_tree.pipeline_current_node\[0\]\[5\] tree_instances\[5\].u_tree.pipeline_current_node\[0\]\[6\]
+ VGND VGND VPWR VPWR _1765_ sky130_fd_sc_hd__nor2_1
X_3388_ tree_instances\[2\].u_tree.frame_id_out\[3\] tree_instances\[2\].u_tree.pipeline_frame_id\[0\]\[3\]
+ _1891_ VGND VGND VPWR VPWR _0991_ sky130_fd_sc_hd__mux2_1
X_2339_ _1702_ VGND VGND VPWR VPWR _1703_ sky130_fd_sc_hd__clkbuf_1
XTAP_TAPCELL_ROW_4_247 VGND VPWR sky130_fd_sc_hd__tapvpwrvgnd_1
XPHY_EDGE_ROW_2_Right_2 VGND VGND VPWR VPWR sky130_fd_sc_hd__decap_3
X_4009_ tree_instances\[14\].u_tree.pipeline_frame_id\[0\]\[2\] _1165_ _0012_ VGND
+ VGND VPWR VPWR _1366_ sky130_fd_sc_hd__mux2_1
XFILLER_0_67_505 VGND VGND VPWR VPWR sky130_fd_sc_hd__decap_4
Xclkbuf_leaf_64_clk clknet_3_1__leaf_clk VGND VGND VPWR VPWR clknet_leaf_64_clk sky130_fd_sc_hd__clkbuf_4
XFILLER_0_67_538 VGND VGND VPWR VPWR sky130_fd_sc_hd__decap_4
XFILLER_0_35_413 VGND VGND VPWR VPWR sky130_fd_sc_hd__fill_2
XFILLER_0_47_262 VPWR VGND VPWR VGND sky130_ef_sc_hd__decap_12
XFILLER_0_90_552 VPWR VGND VPWR VGND sky130_ef_sc_hd__decap_12
XFILLER_0_15_181 VGND VGND VPWR VPWR sky130_fd_sc_hd__fill_2
XFILLER_0_22_129 VGND VGND VPWR VPWR sky130_fd_sc_hd__decap_4
XANTENNA__3174__B _0650_ VGND VGND VPWR VPWR sky130_fd_sc_hd__diode_2
XFILLER_0_30_195 VGND VGND VPWR VPWR sky130_fd_sc_hd__fill_1
XTAP_TAPCELL_ROW_89_1100 VGND VPWR sky130_fd_sc_hd__tapvpwrvgnd_1
XFILLER_0_26_27 VGND VGND VPWR VPWR sky130_fd_sc_hd__fill_1
XPHY_EDGE_ROW_82_Left_179 VGND VGND VPWR VPWR sky130_fd_sc_hd__decap_3
XTAP_TAPCELL_ROW_74_945 VGND VPWR sky130_fd_sc_hd__tapvpwrvgnd_1
Xclkbuf_leaf_55_clk clknet_3_4__leaf_clk VGND VGND VPWR VPWR clknet_leaf_55_clk sky130_fd_sc_hd__clkbuf_4
XTAP_TAPCELL_ROW_46_669 VGND VPWR sky130_fd_sc_hd__tapvpwrvgnd_1
XFILLER_0_53_221 VGND VGND VPWR VPWR sky130_fd_sc_hd__decap_3
X_2690_ tree_instances\[12\].u_tree.pipeline_current_node\[0\]\[4\] VGND VGND VPWR
+ VPWR _2009_ sky130_fd_sc_hd__clkbuf_1
XFILLER_0_41_405 VGND VGND VPWR VPWR sky130_fd_sc_hd__decap_3
XPHY_EDGE_ROW_91_Left_188 VGND VGND VPWR VPWR sky130_fd_sc_hd__decap_3
XFILLER_0_6_15 VPWR VGND VPWR VGND sky130_ef_sc_hd__decap_12
X_4360_ clknet_leaf_7_clk _0120_ net12 VGND VGND VPWR VPWR complete_votes\[4\] sky130_fd_sc_hd__dfrtp_1
X_3311_ _0944_ VGND VGND VPWR VPWR _0154_ sky130_fd_sc_hd__clkbuf_1
X_4291_ _1528_ VGND VGND VPWR VPWR _0550_ sky130_fd_sc_hd__clkbuf_1
XFILLER_0_67_34 VGND VGND VPWR VPWR sky130_fd_sc_hd__fill_2
X_3242_ _0651_ _0649_ _0655_ VGND VGND VPWR VPWR _0907_ sky130_fd_sc_hd__a21oi_1
X_3173_ _0703_ tree_instances\[20\].u_tree.frame_id_out\[2\] tree_instances\[20\].u_tree.frame_id_out\[3\]
+ _0689_ _0844_ VGND VGND VPWR VPWR _0845_ sky130_fd_sc_hd__o221a_1
XTAP_TAPCELL_ROW_1_217 VGND VPWR sky130_fd_sc_hd__tapvpwrvgnd_1
XFILLER_0_83_99 VGND VGND VPWR VPWR sky130_fd_sc_hd__decap_6
Xclkbuf_leaf_46_clk clknet_3_5__leaf_clk VGND VGND VPWR VPWR clknet_leaf_46_clk sky130_fd_sc_hd__clkbuf_4
XFILLER_0_88_184 VGND VGND VPWR VPWR sky130_fd_sc_hd__decap_8
XANTENNA__3470__A1 _0665_ VGND VGND VPWR VPWR sky130_fd_sc_hd__diode_2
XFILLER_0_49_527 VGND VGND VPWR VPWR sky130_fd_sc_hd__fill_1
XANTENNA__4687__RESET_B net11 VGND VGND VPWR VPWR sky130_fd_sc_hd__diode_2
XFILLER_0_29_240 VGND VGND VPWR VPWR sky130_fd_sc_hd__fill_1
XFILLER_0_91_305 VPWR VGND VPWR VGND sky130_ef_sc_hd__decap_12
XTAP_TAPCELL_ROW_17_382 VGND VPWR sky130_fd_sc_hd__tapvpwrvgnd_1
XANTENNA__4616__RESET_B tree_instances\[0\].u_tree.rst_n VGND VGND VPWR VPWR sky130_fd_sc_hd__diode_2
XFILLER_0_17_446 VGND VGND VPWR VPWR sky130_fd_sc_hd__fill_2
XFILLER_0_32_70 VPWR VGND VPWR VGND sky130_ef_sc_hd__decap_12
X_2957_ tree_instances\[15\].u_tree.tree_state\[0\] VGND VGND VPWR VPWR _0641_ sky130_fd_sc_hd__inv_2
XFILLER_0_96_3 VPWR VGND VPWR VGND sky130_ef_sc_hd__decap_12
X_2888_ tree_instances\[10\].u_tree.pipeline_current_node\[0\]\[8\] VGND VGND VPWR
+ VPWR _0595_ sky130_fd_sc_hd__clkbuf_1
XFILLER_0_44_265 VGND VGND VPWR VPWR sky130_fd_sc_hd__decap_4
X_4627_ clknet_leaf_2_clk _0337_ net9 VGND VGND VPWR VPWR tree_instances\[10\].u_tree.pipeline_current_node\[0\]\[2\]
+ sky130_fd_sc_hd__dfrtp_1
XFILLER_0_32_438 VGND VGND VPWR VPWR sky130_fd_sc_hd__fill_2
XFILLER_0_4_373 VGND VGND VPWR VPWR sky130_fd_sc_hd__decap_3
XANTENNA__3275__A _0678_ VGND VGND VPWR VPWR sky130_fd_sc_hd__diode_2
X_4558_ clknet_leaf_66_clk _0279_ tree_instances\[0\].u_tree.rst_n VGND VGND VPWR
+ VPWR tree_instances\[7\].u_tree.pipeline_current_node\[0\]\[5\] sky130_fd_sc_hd__dfrtp_1
X_3509_ _1063_ VGND VGND VPWR VPWR _0233_ sky130_fd_sc_hd__clkbuf_1
X_4489_ clknet_leaf_56_clk _0229_ tree_instances\[0\].u_tree.rst_n VGND VGND VPWR
+ VPWR tree_instances\[4\].u_tree.ready_for_next sky130_fd_sc_hd__dfstp_1
Xclkbuf_leaf_37_clk clknet_3_7__leaf_clk VGND VGND VPWR VPWR clknet_leaf_37_clk sky130_fd_sc_hd__clkbuf_4
XTAP_TAPCELL_ROW_84_1052 VGND VPWR sky130_fd_sc_hd__tapvpwrvgnd_1
XTAP_TAPCELL_ROW_71_915 VGND VPWR sky130_fd_sc_hd__tapvpwrvgnd_1
XFILLER_0_94_121 VGND VGND VPWR VPWR sky130_fd_sc_hd__fill_1
XTAP_TAPCELL_ROW_43_639 VGND VPWR sky130_fd_sc_hd__tapvpwrvgnd_1
XANTENNA__4357__RESET_B net11 VGND VGND VPWR VPWR sky130_fd_sc_hd__diode_2
XFILLER_0_12_29 VGND VGND VPWR VPWR sky130_fd_sc_hd__fill_1
XFILLER_0_35_232 VGND VGND VPWR VPWR sky130_fd_sc_hd__fill_2
XFILLER_0_23_405 VGND VGND VPWR VPWR sky130_fd_sc_hd__fill_1
XFILLER_0_50_213 VGND VGND VPWR VPWR sky130_fd_sc_hd__fill_1
XANTENNA__3185__A _0650_ VGND VGND VPWR VPWR sky130_fd_sc_hd__diode_2
XFILLER_0_23_449 VGND VGND VPWR VPWR sky130_fd_sc_hd__fill_2
XANTENNA__2801__B _1827_ VGND VGND VPWR VPWR sky130_fd_sc_hd__diode_2
Xoutput5 net5 VGND VGND VPWR VPWR frame_id_out[3] sky130_fd_sc_hd__buf_8
XFILLER_0_37_26 VGND VGND VPWR VPWR sky130_fd_sc_hd__fill_1
Xclkbuf_leaf_28_clk clknet_3_6__leaf_clk VGND VGND VPWR VPWR clknet_leaf_28_clk sky130_fd_sc_hd__clkbuf_4
XTAP_TAPCELL_ROW_59_794 VGND VPWR sky130_fd_sc_hd__tapvpwrvgnd_1
XFILLER_0_58_313 VGND VGND VPWR VPWR sky130_fd_sc_hd__fill_1
XFILLER_0_53_69 VGND VGND VPWR VPWR sky130_fd_sc_hd__decap_3
XANTENNA__4780__RESET_B net13 VGND VGND VPWR VPWR sky130_fd_sc_hd__diode_2
X_3860_ tree_instances\[11\].u_tree.frame_id_out\[3\] tree_instances\[11\].u_tree.pipeline_frame_id\[0\]\[3\]
+ _1595_ VGND VGND VPWR VPWR _1274_ sky130_fd_sc_hd__mux2_1
XANTENNA_clkbuf_leaf_32_clk_A clknet_3_6__leaf_clk VGND VGND VPWR VPWR sky130_fd_sc_hd__diode_2
XTAP_TAPCELL_ROW_14_352 VGND VPWR sky130_fd_sc_hd__tapvpwrvgnd_1
X_2811_ _1838_ VGND VGND VPWR VPWR _2115_ sky130_fd_sc_hd__clkbuf_1
XFILLER_0_26_210 VGND VGND VPWR VPWR sky130_fd_sc_hd__fill_2
X_3791_ _1238_ VGND VGND VPWR VPWR _0340_ sky130_fd_sc_hd__clkbuf_1
X_2742_ tree_instances\[16\].u_tree.pipeline_current_node\[0\]\[0\] VGND VGND VPWR
+ VPWR _2053_ sky130_fd_sc_hd__clkbuf_1
XFILLER_0_81_393 VGND VGND VPWR VPWR sky130_fd_sc_hd__fill_1
X_4412_ clknet_leaf_22_clk _0159_ net11 VGND VGND VPWR VPWR tree_instances\[1\].u_tree.pipeline_frame_id\[0\]\[3\]
+ sky130_fd_sc_hd__dfrtp_1
X_2673_ _1994_ VGND VGND VPWR VPWR _0085_ sky130_fd_sc_hd__clkbuf_1
XANTENNA_clkbuf_leaf_47_clk_A clknet_3_5__leaf_clk VGND VGND VPWR VPWR sky130_fd_sc_hd__diode_2
XFILLER_0_41_246 VGND VGND VPWR VPWR sky130_fd_sc_hd__fill_2
XFILLER_0_78_55 VPWR VGND VPWR VGND sky130_ef_sc_hd__decap_12
XFILLER_0_1_332 VGND VGND VPWR VPWR sky130_fd_sc_hd__decap_4
XFILLER_0_22_471 VGND VGND VPWR VPWR sky130_fd_sc_hd__decap_4
X_4343_ clknet_leaf_12_clk _0006_ tree_instances\[0\].u_tree.rst_n VGND VGND VPWR
+ VPWR tree_instances\[11\].u_tree.tree_state\[2\] sky130_fd_sc_hd__dfrtp_1
X_4274_ _1519_ VGND VGND VPWR VPWR _0542_ sky130_fd_sc_hd__clkbuf_1
X_3225_ _0887_ _0892_ _0890_ _0894_ _0645_ VGND VGND VPWR VPWR _0118_ sky130_fd_sc_hd__o311a_1
X_3156_ tree_instances\[10\].u_tree.frame_id_out\[4\] VGND VGND VPWR VPWR _0828_ sky130_fd_sc_hd__inv_2
XANTENNA__4868__RESET_B net10 VGND VGND VPWR VPWR sky130_fd_sc_hd__diode_2
Xclkbuf_leaf_19_clk clknet_3_3__leaf_clk VGND VGND VPWR VPWR clknet_leaf_19_clk sky130_fd_sc_hd__clkbuf_4
X_3087_ _0685_ tree_instances\[18\].u_tree.frame_id_out\[1\] _0757_ _0658_ _0758_
+ VGND VGND VPWR VPWR _0759_ sky130_fd_sc_hd__a221o_1
XFILLER_0_11_3 VGND VGND VPWR VPWR sky130_fd_sc_hd__decap_8
XFILLER_0_76_176 VGND VGND VPWR VPWR sky130_fd_sc_hd__decap_6
XANTENNA__4450__RESET_B tree_instances\[0\].u_tree.rst_n VGND VGND VPWR VPWR sky130_fd_sc_hd__diode_2
XFILLER_0_91_113 VGND VGND VPWR VPWR sky130_fd_sc_hd__decap_4
XFILLER_0_64_349 VGND VGND VPWR VPWR sky130_fd_sc_hd__decap_8
XTAP_TAPCELL_ROW_40_609 VGND VPWR sky130_fd_sc_hd__tapvpwrvgnd_1
X_3989_ _1285_ _1354_ VGND VGND VPWR VPWR _1356_ sky130_fd_sc_hd__and2_1
XFILLER_0_60_533 VPWR VGND VPWR VGND sky130_ef_sc_hd__decap_12
XFILLER_0_17_276 VGND VGND VPWR VPWR sky130_fd_sc_hd__decap_4
XFILLER_0_7_80 VGND VGND VPWR VPWR sky130_fd_sc_hd__fill_2
XANTENNA__4538__RESET_B net11 VGND VGND VPWR VPWR sky130_fd_sc_hd__diode_2
XTAP_TAPCELL_ROW_56_764 VGND VPWR sky130_fd_sc_hd__tapvpwrvgnd_1
XTAP_TAPCELL_ROW_28_488 VGND VPWR sky130_fd_sc_hd__tapvpwrvgnd_1
XFILLER_0_95_485 VPWR VGND VPWR VGND sky130_ef_sc_hd__decap_12
XFILLER_0_28_508 VGND VGND VPWR VPWR sky130_fd_sc_hd__decap_8
XTAP_TAPCELL_ROW_11_322 VGND VPWR sky130_fd_sc_hd__tapvpwrvgnd_1
XFILLER_0_63_393 VGND VGND VPWR VPWR sky130_fd_sc_hd__decap_6
XFILLER_0_23_268 VPWR VGND VPWR VGND sky130_ef_sc_hd__decap_12
X_3010_ _0682_ _0680_ VGND VGND VPWR VPWR _0115_ sky130_fd_sc_hd__xnor2_1
XFILLER_0_78_419 VGND VGND VPWR VPWR sky130_fd_sc_hd__fill_1
XTAP_TAPCELL_ROW_19_400 VGND VPWR sky130_fd_sc_hd__tapvpwrvgnd_1
XFILLER_0_86_430 VPWR VGND VPWR VGND sky130_ef_sc_hd__decap_12
X_3912_ _1308_ VGND VGND VPWR VPWR _0391_ sky130_fd_sc_hd__clkbuf_1
XANTENNA__3095__A1_N _0690_ VGND VGND VPWR VPWR sky130_fd_sc_hd__diode_2
X_4892_ clknet_leaf_44_clk _0564_ net11 VGND VGND VPWR VPWR tree_instances\[20\].u_tree.frame_id_out\[3\]
+ sky130_fd_sc_hd__dfrtp_1
X_3843_ _1265_ VGND VGND VPWR VPWR _0365_ sky130_fd_sc_hd__clkbuf_1
XFILLER_0_39_390 VGND VGND VPWR VPWR sky130_fd_sc_hd__fill_2
XFILLER_0_46_327 VPWR VGND VPWR VGND sky130_ef_sc_hd__decap_12
XFILLER_0_46_349 VGND VGND VPWR VPWR sky130_fd_sc_hd__fill_1
XFILLER_0_73_157 VGND VGND VPWR VPWR sky130_fd_sc_hd__fill_2
X_3774_ tree_instances\[9\].u_tree.tree_state\[0\] _1648_ VGND VGND VPWR VPWR _1229_
+ sky130_fd_sc_hd__nand2_1
XFILLER_0_13_94 VGND VGND VPWR VPWR sky130_fd_sc_hd__decap_8
XFILLER_0_6_457 VPWR VGND VPWR VGND sky130_ef_sc_hd__decap_12
XFILLER_0_89_54 VGND VGND VPWR VPWR sky130_fd_sc_hd__fill_2
X_2725_ _2031_ VGND VGND VPWR VPWR _2041_ sky130_fd_sc_hd__clkbuf_1
XFILLER_0_42_533 VPWR VGND VPWR VGND sky130_ef_sc_hd__decap_12
X_2656_ _1975_ VGND VGND VPWR VPWR _1978_ sky130_fd_sc_hd__clkbuf_1
Xclkbuf_leaf_8_clk clknet_3_3__leaf_clk VGND VGND VPWR VPWR clknet_leaf_8_clk sky130_fd_sc_hd__clkbuf_4
X_2587_ _1918_ _1919_ VGND VGND VPWR VPWR _1920_ sky130_fd_sc_hd__nor2_1
XFILLER_0_59_3 VGND VGND VPWR VPWR sky130_fd_sc_hd__decap_8
X_4326_ _1646_ _1544_ _1546_ VGND VGND VPWR VPWR _1547_ sky130_fd_sc_hd__and3_1
XFILLER_0_10_474 VGND VGND VPWR VPWR sky130_fd_sc_hd__fill_2
X_4257_ tree_instances\[19\].u_tree.pipeline_current_node\[0\]\[8\] _1501_ VGND VGND
+ VPWR VPWR _1511_ sky130_fd_sc_hd__and2_1
XFILLER_0_38_80 VGND VGND VPWR VPWR sky130_fd_sc_hd__fill_1
X_4188_ tree_instances\[17\].u_tree.frame_id_out\[4\] tree_instances\[17\].u_tree.pipeline_frame_id\[0\]\[4\]
+ tree_instances\[17\].u_tree.tree_state\[3\] VGND VGND VPWR VPWR _1475_ sky130_fd_sc_hd__mux2_1
X_3208_ _0660_ tree_instances\[5\].u_tree.frame_id_out\[4\] VGND VGND VPWR VPWR _0880_
+ sky130_fd_sc_hd__nor2_1
X_3139_ _0647_ tree_instances\[9\].u_tree.frame_id_out\[0\] tree_instances\[9\].u_tree.frame_id_out\[2\]
+ _0704_ VGND VGND VPWR VPWR _0811_ sky130_fd_sc_hd__o22a_1
XANTENNA__4631__RESET_B net9 VGND VGND VPWR VPWR sky130_fd_sc_hd__diode_2
XFILLER_0_96_249 VGND VGND VPWR VPWR sky130_fd_sc_hd__decap_3
XFILLER_0_77_441 VGND VGND VPWR VPWR sky130_fd_sc_hd__decap_3
XANTENNA__3416__A1 _0665_ VGND VGND VPWR VPWR sky130_fd_sc_hd__diode_2
XFILLER_0_49_132 VGND VGND VPWR VPWR sky130_fd_sc_hd__decap_8
XTAP_TAPCELL_ROW_81_1022 VGND VPWR sky130_fd_sc_hd__tapvpwrvgnd_1
XTAP_TAPCELL_ROW_25_458 VGND VPWR sky130_fd_sc_hd__tapvpwrvgnd_1
XTAP_TAPCELL_ROW_53_734 VGND VPWR sky130_fd_sc_hd__tapvpwrvgnd_1
XFILLER_0_92_477 VGND VGND VPWR VPWR sky130_fd_sc_hd__decap_6
XFILLER_0_45_393 VPWR VGND VPWR VGND sky130_ef_sc_hd__decap_12
XFILLER_0_33_566 VGND VGND VPWR VPWR sky130_fd_sc_hd__decap_8
XFILLER_0_0_3 VPWR VGND VPWR VGND sky130_ef_sc_hd__decap_12
XANTENNA__3104__B1 _0662_ VGND VGND VPWR VPWR sky130_fd_sc_hd__diode_2
XANTENNA__4719__RESET_B tree_instances\[0\].u_tree.rst_n VGND VGND VPWR VPWR sky130_fd_sc_hd__diode_2
XANTENNA__4372__RESET_B net12 VGND VGND VPWR VPWR sky130_fd_sc_hd__diode_2
XFILLER_0_50_15 VGND VGND VPWR VPWR sky130_fd_sc_hd__decap_8
XFILLER_0_55_113 VGND VGND VPWR VPWR sky130_fd_sc_hd__fill_2
XFILLER_0_50_26 VGND VGND VPWR VPWR sky130_fd_sc_hd__fill_2
XFILLER_0_55_146 VGND VGND VPWR VPWR sky130_fd_sc_hd__decap_3
XFILLER_0_3_405 VPWR VGND VPWR VGND sky130_ef_sc_hd__decap_12
XFILLER_0_24_533 VPWR VGND VPWR VGND sky130_ef_sc_hd__decap_12
XFILLER_0_36_393 VGND VGND VPWR VPWR sky130_fd_sc_hd__decap_4
XFILLER_0_51_341 VGND VGND VPWR VPWR sky130_fd_sc_hd__decap_8
XFILLER_0_11_205 VPWR VGND VPWR VGND sky130_ef_sc_hd__decap_12
X_2510_ _1842_ _1855_ VGND VGND VPWR VPWR _1856_ sky130_fd_sc_hd__nor2_1
XFILLER_0_3_449 VPWR VGND VPWR VGND sky130_ef_sc_hd__decap_12
X_3490_ tree_instances\[4\].u_tree.tree_state\[0\] _1833_ VGND VGND VPWR VPWR _1049_
+ sky130_fd_sc_hd__nand2_1
X_2441_ tree_instances\[10\].u_tree.pipeline_current_node\[0\]\[8\] VGND VGND VPWR
+ VPWR _1794_ sky130_fd_sc_hd__inv_2
XFILLER_0_11_249 VPWR VGND VPWR VGND sky130_ef_sc_hd__decap_12
X_2372_ tree_instances\[14\].u_tree.pipeline_current_node\[0\]\[4\] VGND VGND VPWR
+ VPWR _1733_ sky130_fd_sc_hd__clkbuf_1
X_4111_ _1418_ VGND VGND VPWR VPWR _0480_ sky130_fd_sc_hd__clkbuf_1
X_4042_ _1326_ _1376_ VGND VGND VPWR VPWR _1383_ sky130_fd_sc_hd__and2_1
XFILLER_0_19_305 VPWR VGND VPWR VGND sky130_ef_sc_hd__decap_12
XFILLER_0_59_485 VGND VGND VPWR VPWR sky130_fd_sc_hd__fill_2
XFILLER_0_24_71 VGND VGND VPWR VPWR sky130_fd_sc_hd__decap_8
XFILLER_0_46_113 VPWR VGND VPWR VGND sky130_ef_sc_hd__decap_12
XTAP_TAPCELL_ROW_50_704 VGND VPWR sky130_fd_sc_hd__tapvpwrvgnd_1
XFILLER_0_74_455 VPWR VGND VPWR VGND sky130_ef_sc_hd__decap_12
X_4875_ clknet_leaf_40_clk _0547_ net10 VGND VGND VPWR VPWR tree_instances\[20\].u_tree.pipeline_current_node\[0\]\[0\]
+ sky130_fd_sc_hd__dfrtp_1
XTAP_TAPCELL_ROW_22_428 VGND VPWR sky130_fd_sc_hd__tapvpwrvgnd_1
XFILLER_0_74_477 VGND VGND VPWR VPWR sky130_fd_sc_hd__fill_1
X_3826_ _1256_ VGND VGND VPWR VPWR _0357_ sky130_fd_sc_hd__clkbuf_1
XANTENNA__2171__B _1552_ VGND VGND VPWR VPWR sky130_fd_sc_hd__diode_2
XFILLER_0_61_149 VGND VGND VPWR VPWR sky130_fd_sc_hd__fill_1
X_3757_ _1220_ VGND VGND VPWR VPWR _0324_ sky130_fd_sc_hd__clkbuf_1
X_2708_ _1834_ _2025_ VGND VGND VPWR VPWR _2026_ sky130_fd_sc_hd__and2_1
X_3688_ _2084_ _1179_ VGND VGND VPWR VPWR _1181_ sky130_fd_sc_hd__and2_1
XFILLER_0_42_385 VGND VGND VPWR VPWR sky130_fd_sc_hd__decap_8
XFILLER_0_2_471 VGND VGND VPWR VPWR sky130_fd_sc_hd__decap_4
X_2639_ _1960_ _1964_ VGND VGND VPWR VPWR _1965_ sky130_fd_sc_hd__nor2_1
XANTENNA__4883__RESET_B net10 VGND VGND VPWR VPWR sky130_fd_sc_hd__diode_2
X_4309_ _1537_ VGND VGND VPWR VPWR _0559_ sky130_fd_sc_hd__clkbuf_1
XANTENNA__4812__RESET_B net12 VGND VGND VPWR VPWR sky130_fd_sc_hd__diode_2
XANTENNA__4318__S _1908_ VGND VGND VPWR VPWR sky130_fd_sc_hd__diode_2
XTAP_TAPCELL_ROW_66_870 VGND VPWR sky130_fd_sc_hd__tapvpwrvgnd_1
XFILLER_0_37_113 VGND VGND VPWR VPWR sky130_fd_sc_hd__fill_2
XFILLER_0_92_230 VGND VGND VPWR VPWR sky130_fd_sc_hd__fill_2
XFILLER_0_20_29 VPWR VGND VPWR VGND sky130_ef_sc_hd__decap_12
XFILLER_0_52_149 VGND VGND VPWR VPWR sky130_fd_sc_hd__fill_2
XFILLER_0_52_138 VGND VGND VPWR VPWR sky130_fd_sc_hd__fill_2
XFILLER_0_33_341 VPWR VGND VPWR VGND sky130_ef_sc_hd__decap_12
XANTENNA__3193__A _0653_ VGND VGND VPWR VPWR sky130_fd_sc_hd__diode_2
XFILLER_0_29_27 VGND VGND VPWR VPWR sky130_fd_sc_hd__fill_2
XANTENNA__4553__RESET_B tree_instances\[0\].u_tree.rst_n VGND VGND VPWR VPWR sky130_fd_sc_hd__diode_2
XFILLER_0_45_15 VPWR VGND VPWR VGND sky130_ef_sc_hd__decap_12
XFILLER_0_88_525 VGND VGND VPWR VPWR sky130_fd_sc_hd__fill_2
XFILLER_0_75_219 VGND VGND VPWR VPWR sky130_fd_sc_hd__fill_2
XANTENNA__2971__S _0645_ VGND VGND VPWR VPWR sky130_fd_sc_hd__diode_2
X_2990_ tree_instances\[15\].u_tree.ready_for_next tree_instances\[16\].u_tree.ready_for_next
+ tree_instances\[18\].u_tree.ready_for_next _0666_ VGND VGND VPWR VPWR _0667_ sky130_fd_sc_hd__and4_1
XFILLER_0_61_47 VGND VGND VPWR VPWR sky130_fd_sc_hd__decap_8
XFILLER_0_28_113 VGND VGND VPWR VPWR sky130_fd_sc_hd__fill_2
XFILLER_0_83_241 VGND VGND VPWR VPWR sky130_fd_sc_hd__decap_8
XFILLER_0_61_69 VPWR VGND VPWR VGND sky130_ef_sc_hd__decap_12
XANTENNA__3800__A1 _1124_ VGND VGND VPWR VPWR sky130_fd_sc_hd__diode_2
XFILLER_0_56_444 VGND VGND VPWR VPWR sky130_fd_sc_hd__fill_1
XFILLER_0_83_274 VGND VGND VPWR VPWR sky130_fd_sc_hd__decap_3
X_4660_ clknet_leaf_12_clk _0365_ net12 VGND VGND VPWR VPWR tree_instances\[11\].u_tree.pipeline_current_node\[0\]\[8\]
+ sky130_fd_sc_hd__dfrtp_1
XFILLER_0_9_15 VPWR VGND VPWR VGND sky130_ef_sc_hd__decap_12
XFILLER_0_56_477 VGND VGND VPWR VPWR sky130_fd_sc_hd__decap_8
X_3611_ _1130_ VGND VGND VPWR VPWR _0268_ sky130_fd_sc_hd__clkbuf_1
X_4591_ clknet_leaf_8_clk _0311_ net12 VGND VGND VPWR VPWR tree_instances\[8\].u_tree.frame_id_out\[3\]
+ sky130_fd_sc_hd__dfrtp_1
XFILLER_0_3_235 VGND VGND VPWR VPWR sky130_fd_sc_hd__decap_6
XFILLER_0_24_363 VGND VGND VPWR VPWR sky130_fd_sc_hd__fill_1
X_3542_ _1084_ VGND VGND VPWR VPWR _0245_ sky130_fd_sc_hd__clkbuf_1
XFILLER_0_12_569 VGND VGND VPWR VPWR sky130_fd_sc_hd__decap_4
X_3473_ _1040_ VGND VGND VPWR VPWR _0220_ sky130_fd_sc_hd__clkbuf_1
X_2424_ _1777_ VGND VGND VPWR VPWR _1778_ sky130_fd_sc_hd__clkbuf_1
X_2355_ _1717_ VGND VGND VPWR VPWR _1718_ sky130_fd_sc_hd__clkbuf_1
X_2286_ _1656_ tree_instances\[8\].u_tree.pipeline_current_node\[0\]\[5\] VGND VGND
+ VPWR VPWR _1657_ sky130_fd_sc_hd__nor2_1
X_4025_ _1889_ _0994_ _0636_ tree_instances\[14\].u_tree.ready_for_next VGND VGND
+ VPWR VPWR _0439_ sky130_fd_sc_hd__a22o_1
XFILLER_0_79_558 VGND VGND VPWR VPWR sky130_fd_sc_hd__fill_2
XTAP_TAPCELL_ROW_63_840 VGND VPWR sky130_fd_sc_hd__tapvpwrvgnd_1
XFILLER_0_35_81 VGND VGND VPWR VPWR sky130_fd_sc_hd__decap_3
XFILLER_0_19_113 VPWR VGND VPWR VGND sky130_ef_sc_hd__decap_12
XFILLER_0_59_293 VGND VGND VPWR VPWR sky130_fd_sc_hd__fill_1
XFILLER_0_19_157 VGND VGND VPWR VPWR sky130_fd_sc_hd__fill_1
X_4858_ clknet_leaf_35_clk _0539_ net10 VGND VGND VPWR VPWR tree_instances\[19\].u_tree.pipeline_frame_id\[0\]\[4\]
+ sky130_fd_sc_hd__dfrtp_1
XFILLER_0_7_541 VPWR VGND VPWR VGND sky130_ef_sc_hd__decap_12
XFILLER_0_62_458 VGND VGND VPWR VPWR sky130_fd_sc_hd__fill_2
X_3809_ _1247_ VGND VGND VPWR VPWR _0349_ sky130_fd_sc_hd__clkbuf_1
X_4789_ clknet_leaf_44_clk _0477_ net10 VGND VGND VPWR VPWR tree_instances\[16\].u_tree.frame_id_out\[1\]
+ sky130_fd_sc_hd__dfrtp_1
XTAP_TAPCELL_ROW_7_278 VGND VPWR sky130_fd_sc_hd__tapvpwrvgnd_1
XTAP_TAPCELL_ROW_87_1083 VGND VPWR sky130_fd_sc_hd__tapvpwrvgnd_1
XFILLER_0_57_219 VGND VGND VPWR VPWR sky130_fd_sc_hd__decap_4
XFILLER_0_38_411 VGND VGND VPWR VPWR sky130_fd_sc_hd__fill_2
XFILLER_0_93_561 VPWR VGND VPWR VGND sky130_ef_sc_hd__decap_12
XANTENNA__3188__A _0653_ VGND VGND VPWR VPWR sky130_fd_sc_hd__diode_2
XFILLER_0_38_477 VGND VGND VPWR VPWR sky130_fd_sc_hd__decap_8
XFILLER_0_80_277 VGND VGND VPWR VPWR sky130_fd_sc_hd__fill_1
XFILLER_0_80_266 VGND VGND VPWR VPWR sky130_fd_sc_hd__fill_2
XFILLER_0_21_355 VGND VGND VPWR VPWR sky130_fd_sc_hd__decap_8
XANTENNA__4734__RESET_B net11 VGND VGND VPWR VPWR sky130_fd_sc_hd__diode_2
XFILLER_0_0_249 VGND VGND VPWR VPWR sky130_fd_sc_hd__decap_3
XFILLER_0_21_366 VGND VGND VPWR VPWR sky130_fd_sc_hd__decap_8
XTAP_TAPCELL_ROW_77_976 VGND VPWR sky130_fd_sc_hd__tapvpwrvgnd_1
XFILLER_0_48_219 VGND VGND VPWR VPWR sky130_fd_sc_hd__fill_1
XTAP_TAPCELL_ROW_60_810 VGND VPWR sky130_fd_sc_hd__tapvpwrvgnd_1
X_2973_ current_voting_frame\[2\] VGND VGND VPWR VPWR _0653_ sky130_fd_sc_hd__buf_4
X_4712_ clknet_leaf_4_clk _0415_ net9 VGND VGND VPWR VPWR tree_instances\[13\].u_tree.frame_id_out\[2\]
+ sky130_fd_sc_hd__dfrtp_1
XFILLER_0_71_211 VGND VGND VPWR VPWR sky130_fd_sc_hd__decap_3
XFILLER_0_44_458 VPWR VGND VPWR VGND sky130_ef_sc_hd__decap_12
XFILLER_0_71_277 VGND VGND VPWR VPWR sky130_fd_sc_hd__decap_3
XFILLER_0_4_533 VPWR VGND VPWR VGND sky130_ef_sc_hd__decap_12
XFILLER_0_31_108 VGND VGND VPWR VPWR sky130_fd_sc_hd__fill_1
X_4643_ clknet_leaf_11_clk _0353_ tree_instances\[0\].u_tree.rst_n VGND VGND VPWR
+ VPWR tree_instances\[10\].u_tree.frame_id_out\[4\] sky130_fd_sc_hd__dfrtp_1
X_4574_ clknet_leaf_16_clk _0294_ net12 VGND VGND VPWR VPWR tree_instances\[8\].u_tree.pipeline_current_node\[0\]\[0\]
+ sky130_fd_sc_hd__dfrtp_1
XFILLER_0_12_355 VGND VGND VPWR VPWR sky130_fd_sc_hd__decap_8
X_3525_ _1075_ _1054_ VGND VGND VPWR VPWR _1076_ sky130_fd_sc_hd__and2_1
XFILLER_0_12_377 VGND VGND VPWR VPWR sky130_fd_sc_hd__decap_6
XANTENNA__4475__RESET_B tree_instances\[0\].u_tree.rst_n VGND VGND VPWR VPWR sky130_fd_sc_hd__diode_2
XANTENNA__4404__RESET_B net11 VGND VGND VPWR VPWR sky130_fd_sc_hd__diode_2
X_3456_ _1822_ _1029_ VGND VGND VPWR VPWR _1032_ sky130_fd_sc_hd__and2_1
X_2407_ _1763_ VGND VGND VPWR VPWR _1764_ sky130_fd_sc_hd__inv_2
X_3387_ _0990_ VGND VGND VPWR VPWR _0184_ sky130_fd_sc_hd__clkbuf_1
XFILLER_0_41_3 VGND VGND VPWR VPWR sky130_fd_sc_hd__decap_6
X_2338_ tree_instances\[6\].u_tree.pipeline_current_node\[0\]\[0\] tree_instances\[6\].u_tree.pipeline_current_node\[0\]\[2\]
+ VGND VGND VPWR VPWR _1702_ sky130_fd_sc_hd__or2_1
XTAP_TAPCELL_ROW_4_248 VGND VPWR sky130_fd_sc_hd__tapvpwrvgnd_1
X_2269_ _1630_ _1634_ _1638_ _1643_ VGND VGND VPWR VPWR _1644_ sky130_fd_sc_hd__or4bb_1
XANTENNA__4265__A1 _0678_ VGND VGND VPWR VPWR sky130_fd_sc_hd__diode_2
X_4008_ _1365_ VGND VGND VPWR VPWR _0430_ sky130_fd_sc_hd__clkbuf_1
XFILLER_0_79_399 VGND VGND VPWR VPWR sky130_fd_sc_hd__fill_1
XANTENNA__3225__C1 _0645_ VGND VGND VPWR VPWR sky130_fd_sc_hd__diode_2
XFILLER_0_90_531 VGND VGND VPWR VPWR sky130_fd_sc_hd__fill_1
XFILLER_0_62_211 VGND VGND VPWR VPWR sky130_fd_sc_hd__decap_3
XFILLER_0_47_296 VGND VGND VPWR VPWR sky130_fd_sc_hd__decap_4
XFILLER_0_90_564 VGND VGND VPWR VPWR sky130_fd_sc_hd__decap_8
XFILLER_0_62_277 VPWR VGND VPWR VGND sky130_ef_sc_hd__decap_12
XFILLER_0_15_160 VGND VGND VPWR VPWR sky130_fd_sc_hd__decap_8
XTAP_TAPCELL_ROW_89_1101 VGND VPWR sky130_fd_sc_hd__tapvpwrvgnd_1
XFILLER_0_89_108 VGND VGND VPWR VPWR sky130_fd_sc_hd__fill_1
XTAP_TAPCELL_ROW_74_946 VGND VPWR sky130_fd_sc_hd__tapvpwrvgnd_1
XFILLER_0_85_358 VPWR VGND VPWR VGND sky130_ef_sc_hd__decap_12
XFILLER_0_73_509 VGND VGND VPWR VPWR sky130_fd_sc_hd__fill_1
XFILLER_0_38_230 VGND VGND VPWR VPWR sky130_fd_sc_hd__fill_2
XFILLER_0_5_319 VPWR VGND VPWR VGND sky130_ef_sc_hd__decap_12
XFILLER_0_1_503 VGND VGND VPWR VPWR sky130_fd_sc_hd__fill_1
X_3310_ _0575_ _0935_ VGND VGND VPWR VPWR _0944_ sky130_fd_sc_hd__and2_1
XFILLER_0_6_27 VGND VGND VPWR VPWR sky130_fd_sc_hd__fill_1
X_4290_ _1440_ _1524_ VGND VGND VPWR VPWR _1528_ sky130_fd_sc_hd__and2_1
X_3241_ _0651_ _0655_ _0649_ VGND VGND VPWR VPWR _0906_ sky130_fd_sc_hd__and3_1
X_3172_ current_voting_frame\[0\] tree_instances\[20\].u_tree.frame_id_out\[0\] VGND
+ VGND VPWR VPWR _0844_ sky130_fd_sc_hd__xnor2_1
XANTENNA_clkbuf_leaf_6_clk_A clknet_3_1__leaf_clk VGND VGND VPWR VPWR sky130_fd_sc_hd__diode_2
XTAP_TAPCELL_ROW_1_218 VGND VPWR sky130_fd_sc_hd__tapvpwrvgnd_1
XFILLER_0_91_317 VGND VGND VPWR VPWR sky130_fd_sc_hd__decap_3
XTAP_TAPCELL_ROW_17_383 VGND VPWR sky130_fd_sc_hd__tapvpwrvgnd_1
X_2956_ _0640_ VGND VGND VPWR VPWR _0022_ sky130_fd_sc_hd__inv_2
XFILLER_0_8_146 VPWR VGND VPWR VGND sky130_ef_sc_hd__decap_12
XFILLER_0_32_82 VGND VGND VPWR VPWR sky130_fd_sc_hd__fill_2
XFILLER_0_72_564 VGND VGND VPWR VPWR sky130_fd_sc_hd__decap_8
X_2887_ tree_instances\[10\].u_tree.pipeline_current_node\[0\]\[7\] VGND VGND VPWR
+ VPWR _0594_ sky130_fd_sc_hd__clkbuf_1
XFILLER_0_89_3 VPWR VGND VPWR VGND sky130_ef_sc_hd__decap_12
XANTENNA__4656__RESET_B tree_instances\[0\].u_tree.rst_n VGND VGND VPWR VPWR sky130_fd_sc_hd__diode_2
X_4626_ clknet_leaf_2_clk _0336_ net9 VGND VGND VPWR VPWR tree_instances\[10\].u_tree.pipeline_current_node\[0\]\[1\]
+ sky130_fd_sc_hd__dfrtp_1
XFILLER_0_32_417 VGND VGND VPWR VPWR sky130_fd_sc_hd__fill_1
XFILLER_0_4_385 VPWR VGND VPWR VGND sky130_ef_sc_hd__decap_12
XFILLER_0_4_363 VGND VGND VPWR VPWR sky130_fd_sc_hd__fill_1
X_4557_ clknet_leaf_66_clk _0278_ net9 VGND VGND VPWR VPWR tree_instances\[7\].u_tree.pipeline_current_node\[0\]\[4\]
+ sky130_fd_sc_hd__dfrtp_1
XFILLER_0_40_461 VGND VGND VPWR VPWR sky130_fd_sc_hd__decap_6
XFILLER_0_12_174 VGND VGND VPWR VPWR sky130_fd_sc_hd__fill_2
X_3508_ _1062_ _1054_ VGND VGND VPWR VPWR _1063_ sky130_fd_sc_hd__and2_1
X_4488_ clknet_leaf_63_clk _0228_ net9 VGND VGND VPWR VPWR tree_instances\[4\].u_tree.frame_id_out\[4\]
+ sky130_fd_sc_hd__dfrtp_1
X_3439_ tree_instances\[9\].u_tree.pipeline_current_node\[0\]\[0\] VGND VGND VPWR
+ VPWR _1018_ sky130_fd_sc_hd__clkbuf_1
XFILLER_0_79_152 VPWR VGND VPWR VGND sky130_ef_sc_hd__decap_12
XFILLER_0_79_141 VGND VGND VPWR VPWR sky130_fd_sc_hd__decap_3
XTAP_TAPCELL_ROW_71_916 VGND VPWR sky130_fd_sc_hd__tapvpwrvgnd_1
XTAP_TAPCELL_ROW_84_1053 VGND VPWR sky130_fd_sc_hd__tapvpwrvgnd_1
XFILLER_0_82_317 VGND VGND VPWR VPWR sky130_fd_sc_hd__decap_3
XFILLER_0_75_380 VGND VGND VPWR VPWR sky130_fd_sc_hd__fill_2
XANTENNA__4467__SET_B net9 VGND VGND VPWR VPWR sky130_fd_sc_hd__diode_2
XFILLER_0_63_564 VGND VGND VPWR VPWR sky130_fd_sc_hd__decap_8
XFILLER_0_35_266 VGND VGND VPWR VPWR sky130_fd_sc_hd__fill_2
XFILLER_0_90_361 VGND VGND VPWR VPWR sky130_fd_sc_hd__decap_3
XFILLER_0_50_203 VGND VGND VPWR VPWR sky130_fd_sc_hd__fill_1
XTAP_TAPCELL_ROW_95_1160 VGND VPWR sky130_fd_sc_hd__tapvpwrvgnd_1
Xoutput6 net6 VGND VGND VPWR VPWR frame_id_out[4] sky130_fd_sc_hd__buf_8
XFILLER_0_31_494 VGND VGND VPWR VPWR sky130_fd_sc_hd__fill_1
XTAP_TAPCELL_ROW_59_795 VGND VPWR sky130_fd_sc_hd__tapvpwrvgnd_1
XFILLER_0_85_111 VGND VGND VPWR VPWR sky130_fd_sc_hd__fill_1
XFILLER_0_58_336 VGND VGND VPWR VPWR sky130_fd_sc_hd__decap_3
XFILLER_0_85_166 VGND VGND VPWR VPWR sky130_fd_sc_hd__fill_2
XFILLER_0_58_369 VGND VGND VPWR VPWR sky130_fd_sc_hd__decap_3
XFILLER_0_39_572 VGND VGND VPWR VPWR sky130_fd_sc_hd__fill_2
XTAP_TAPCELL_ROW_14_353 VGND VPWR sky130_fd_sc_hd__tapvpwrvgnd_1
X_2810_ _2113_ VGND VGND VPWR VPWR _2114_ sky130_fd_sc_hd__clkbuf_1
X_3790_ _0584_ _1232_ VGND VGND VPWR VPWR _1238_ sky130_fd_sc_hd__and2_1
X_2741_ _1784_ VGND VGND VPWR VPWR _2052_ sky130_fd_sc_hd__clkbuf_1
XFILLER_0_81_361 VGND VGND VPWR VPWR sky130_fd_sc_hd__fill_2
XFILLER_0_26_277 VGND VGND VPWR VPWR sky130_fd_sc_hd__decap_3
X_4411_ clknet_leaf_22_clk _0158_ net11 VGND VGND VPWR VPWR tree_instances\[1\].u_tree.pipeline_frame_id\[0\]\[2\]
+ sky130_fd_sc_hd__dfrtp_1
X_2672_ tree_instances\[0\].u_tree.prediction_valid _1832_ VGND VGND VPWR VPWR _1994_
+ sky130_fd_sc_hd__and2b_1
XFILLER_0_78_67 VPWR VGND VPWR VGND sky130_ef_sc_hd__decap_12
X_4342_ clknet_leaf_12_clk _0005_ tree_instances\[0\].u_tree.rst_n VGND VGND VPWR
+ VPWR tree_instances\[11\].u_tree.tree_state\[1\] sky130_fd_sc_hd__dfrtp_1
X_4273_ tree_instances\[19\].u_tree.frame_id_out\[2\] tree_instances\[19\].u_tree.pipeline_frame_id\[0\]\[2\]
+ _1970_ VGND VGND VPWR VPWR _1519_ sky130_fd_sc_hd__mux2_1
X_3224_ _0885_ _0893_ _0892_ VGND VGND VPWR VPWR _0894_ sky130_fd_sc_hd__o21ai_1
.ends
